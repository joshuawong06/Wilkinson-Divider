# Ansys Electronics Desktop project, version 2025.1
project variables:
  $er_FR4 = 4.4
materials:
  brass: conductivity=15000000
  copper: permeability=0.999991 conductivity=58000000
  FR4_epoxy: permittivity=4.4 dielectric_loss_tangent=0.02
  FR4_epoxy_Wilkinson: permittivity=$er_FR4 dielectric_loss_tangent=0.02
  pec: conductivity=1e+30
  solder: conductivity=7000000
  SolderMask: permittivity=3.1 dielectric_loss_tangent=0.035
  Teflon (tm): permittivity=2.1 dielectric_loss_tangent=0.001
  vacuum: permittivity=1

design Wilkinson_V1 (HFSS, HFSS Terminal Network, model units mm)
variables:
  board_X = 70mm
  board_Y = 35mm
  board_Z = 1.6mm
  W_50 = 2.95794mm  # 50 Ohm trace width
  L_Port1_Trace = 8mm  # Port 1 trace length
  W_70p7 = 1.53mm  # 70.7 Ohm trace width
  Resistor_CtoC = 0.6mm  # 0603 footprint copper to copper distance
  quarterwave_2245 = 24.46mm
  Radius = (quarterwave_2245-(Resistor_CtoC/2))/pi
  L_Parallel = 1mm
  turn_radius = 3mm
  L_Split = 1mm
geometry:
  Ground = rectangle(corner=(-board_X/2, -board_Y/2, 0mm), x_size=board_X, y_size=board_Y)
  Substrate [FR4_epoxy] = box(corner=(-board_X/2, -board_Y/2, 0mm), size=(board_X, board_Y, board_Z))
  Port1_50ohms = rectangle(corner=(-(board_X/4)-(W_50/2), -board_Y/2, 1.6mm), x_size=W_50, y_size=L_Port1_Trace)
  Stub_1 = rectangle(corner=(-(board_X/4)-(Resistor_CtoC/2), -(board_Y/2)+L_Port1_Trace-(W_70p7/2), board_Z), x_size=Resistor_CtoC/2, y_size=W_70p7)
  Stub_2 = rectangle(corner=(-(board_X/4), -(board_Y/2)+L_Port1_Trace-(W_70p7/2), board_Z), x_size=Resistor_CtoC/2, y_size=W_70p7)
  Arc_1_Line = polyline((-(board_X/4)-(Resistor_CtoC/2), -(board_Y/2)+L_Port1_Trace, board_Z) (-25.490367mm, -1.8096331mm, 1.6mm) (-17.8mm, 5.8807337mm, 1.6mm), AngularArc from point 0 over 3 centre=(-(board_X/4)-(Resistor_CtoC/2), -(board_Y/2)+L_Port1_Trace+Radius, board_Z) angle=-180deg plane=XY)
  Arc_1_Line1 = polyline((-(board_X/4)+(Resistor_CtoC/2), -(board_Y/2)+L_Port1_Trace, board_Z) (-9.5096331mm, -1.8096331mm, 1.6mm) (-17.2mm, 5.8807337mm, 1.6mm), AngularArc from point 0 over 3 centre=(-(board_X/4)+(Resistor_CtoC/2), -(board_Y/2)+L_Port1_Trace+Radius, board_Z) angle=180deg plane=XY)
  Arc_1 = polyline((-(board_X/4)-(Resistor_CtoC/2), -(board_Y/2)+L_Port1_Trace-(W_70p7/2), board_Z) (-(board_X/4)-(Resistor_CtoC/2), -(board_Y/2)+L_Port1_Trace+(W_70p7/2), board_Z))
  Arc_1.sweep_along_path(Arc_1_Line)
  Arc_2 = polyline((-(board_X/4)+(Resistor_CtoC/2), -(board_Y/2)+L_Port1_Trace-(W_70p7/2), board_Z) (-(board_X/4)+(Resistor_CtoC/2), -(board_Y/2)+L_Port1_Trace+(W_70p7/2), board_Z))
  Arc_2.sweep_along_path(Arc_1_Line1)
  Resistor_100ohms = rectangle(corner=(-(board_X/4)-(Resistor_CtoC/2), -(board_Y/2)+L_Port1_Trace+2*Radius-(W_70p7 /2), board_Z), x_size=Resistor_CtoC, y_size=0.8mm)
  Copper_Trace = polyline((-(board_X/4)-(Resistor_CtoC/2), -(board_Y/2)+L_Port1_Trace+2*Radius-(W_70p7 /2), board_Z) (-(board_X/4)-(Resistor_CtoC/2)-W_50, -(board_Y/2)+L_Port1_Trace+2*Radius-(W_70p7 /2), board_Z))
  Polyline2 = polyline((-(board_X/4)-(Resistor_CtoC/2)-(W_50/2), -(board_Y/2)+L_Port1_Trace+2*Radius-(W_70p7 /2), board_Z) (-(board_X/4)-(Resistor_CtoC/2)-(W_50/2), -(board_Y/2)+L_Port1_Trace+2*Radius-(W_70p7 /2)+L_Parallel, board_Z))
  Polyline3 = polyline((-(board_X/4)-(Resistor_CtoC/2)-(W_50/2), -(board_Y/2)+L_Port1_Trace+2*Radius-(W_70p7 /2)+L_Parallel, board_Z) (-20.15765mm, 8.237054mm, 1.6mm) (-22.27897mm, 9.1157337mm, 1.6mm), AngularArc from point 0 over 3 centre=(-(board_X/4)-(Resistor_CtoC/2)-(W_50/2)-turn_radius, -(board_Y/2)+L_Port1_Trace+2*Radius-(W_70p7 /2)+L_Parallel, board_Z) angle=90deg plane=XY)
  Polyline4 = polyline((-(board_X/4)-(Resistor_CtoC/2)-(W_50/2)-turn_radius, -(board_Y/2)+L_Port1_Trace+2*Radius-(W_70p7 /2)+L_Parallel+turn_radius, board_Z) (-(board_X/4)-(Resistor_CtoC/2)-(W_50/2)-turn_radius-L_Split, -(board_Y/2)+L_Port1_Trace+2*Radius-(W_70p7 /2)+L_Parallel+turn_radius, board_Z))
  Polyline5 = polyline((-(board_X/4)-(Resistor_CtoC/2)-(W_50/2)-turn_radius-L_Split, -(board_Y/2)+L_Port1_Trace+2*Radius-(W_70p7 /2)+L_Parallel+turn_radius, board_Z) (-25.40029mm, 9.9944134mm, 1.6mm) (-26.27897mm, 12.115734mm, 1.6mm), AngularArc from point 0 over 3 centre=(-(board_X/4)-(Resistor_CtoC/2)-(W_50/2)-turn_radius-L_Split, -(board_Y/2)+L_Port1_Trace+2*Radius-(W_70p7 /2)+L_Parallel+turn_radius+turn_radius, board_Z) angle=-90deg plane=XY)
  Polyline6 = polyline((-(board_X/4)-(Resistor_CtoC/2)-(W_50/2)-turn_radius-L_Split-turn_radius, -(board_Y/2)+L_Port1_Trace+2*Radius-(W_70p7 /2)+L_Parallel+turn_radius+turn_radius, board_Z) (-(board_X/4)-(Resistor_CtoC/2)-(W_50/2)-turn_radius-L_Split-turn_radius, (board_Y/2), board_Z))
  Polyline6.unite(Polyline5, Polyline4, Polyline3, Polyline2)
  Copper_Trace.sweep_along_path(Polyline6)
  Polyline7 = polyline((-(board_X/4)-(Resistor_CtoC/2), -(board_Y/2)+L_Port1_Trace+2*Radius-(W_70p7 /2), board_Z) (-(board_X/4)-(Resistor_CtoC/2)-W_50, -(board_Y/2)+L_Port1_Trace+2*Radius-(W_70p7 /2), board_Z))
  Polyline12 = polyline((-(board_X/4)-(Resistor_CtoC/2)-(W_50/2)-turn_radius-L_Split-turn_radius, -(board_Y/2)+L_Port1_Trace+2*Radius-(W_70p7 /2)+L_Parallel+turn_radius+turn_radius, board_Z) (-(board_X/4)-(Resistor_CtoC/2)-(W_50/2)-turn_radius-L_Split-turn_radius, (board_Y/2), board_Z))
  Polyline11 = polyline((-(board_X/4)-(Resistor_CtoC/2)-(W_50/2)-turn_radius -L_Split, -(board_Y/2)+L_Port1_Trace+2*Radius-(W_70p7 /2)+L_Parallel +turn_radius, board_Z) (-25.40029mm, 9.9944134mm, 1.6mm) (-26.27897mm, 12.115734mm, 1.6mm), AngularArc from point 0 over 3 centre=(-(board_X/4)-(Resistor_CtoC/2)-(W_50/2)-turn_radius -L_Split, -(board_Y/2)+L_Port1_Trace+2*Radius-(W_70p7 /2)+L_Parallel +turn_radius+turn_radius, board_Z) angle=-90deg plane=XY)
  Polyline10 = polyline((-(board_X/4)-(Resistor_CtoC/2)-(W_50/2)-turn_radius, -(board_Y/2)+L_Port1_Trace+2*Radius-(W_70p7 /2)+L_Parallel +turn_radius, board_Z) (-(board_X/4)-(Resistor_CtoC/2)-(W_50/2)-turn_radius -L_Split, -(board_Y/2)+L_Port1_Trace+2*Radius-(W_70p7 /2)+L_Parallel +turn_radius, board_Z))
  Polyline9 = polyline((-(board_X/4)-(Resistor_CtoC/2)-(W_50/2), -(board_Y/2)+L_Port1_Trace+2*Radius-(W_70p7 /2)+L_Parallel, board_Z) (-20.15765mm, 8.237054mm, 1.6mm) (-22.27897mm, 9.1157337mm, 1.6mm), AngularArc from point 0 over 3 centre=(-(board_X/4)-(Resistor_CtoC/2)-(W_50/2)-turn_radius, -(board_Y/2)+L_Port1_Trace+2*Radius-(W_70p7 /2)+L_Parallel, board_Z) angle=90deg plane=XY)
  Polyline8 = polyline((-(board_X/4)-(Resistor_CtoC/2)-(W_50/2), -(board_Y/2)+L_Port1_Trace+2*Radius-(W_70p7 /2), board_Z) (-(board_X/4)-(Resistor_CtoC/2)-(W_50/2), -(board_Y/2)+L_Port1_Trace+2*Radius-(W_70p7 /2)+L_Parallel, board_Z))
  Polyline12.unite(Polyline11, Polyline10, Polyline9, Polyline8)
  Polyline7.sweep_along_path(Polyline12)
  Polyline7.mirror(point=(-board_X/4, 0.9864367mm, 1.6mm), normal=(-1mm, 0mm, 0mm))
  Copper_Trace.unite(Polyline7, Arc_1, Arc_2, Stub_1, Stub_2, Port1_50ohms)
  Port1 = rectangle(corner=(-(board_X/4)-(W_50/2), -board_Y/2, board_Z), z_size=-1.6mm, x_size=W_50)
  Port2 = rectangle(corner=(-(board_X/4)-(Resistor_CtoC/2)-(W_50/2)-turn_radius-L_Split-turn_radius+(W_50/2), (board_Y/2), board_Z), z_size=-1.6mm, x_size=-W_50)
  Port3 = rectangle(corner=(-(board_X/4)+(Resistor_CtoC/2)+(W_50/2) +turn_radius+L_Split+turn_radius+(W_50/2), (board_Y/2), board_Z), z_size=-1.6mm, x_size=-W_50)
  RadiatingSurface [vacuum] = region(absolute_offset=44.54343mm on all sides)
boundaries and excitations:
  Ground: Perfect E Objects=Ground
  LumpRLC1: Lumped RLC Objects=Resistor_100ohms CurrentLine{(-17.8, 5.5157337, 1.6) -> (-17.2, 5.5157337, 1.6)} RLC_Type=Serial Resistance=100ohm
  Copper_Trace: Perfect E Objects=Copper_Trace
  Open1: Radiation Objects=RadiatingSurface
  Port1_T: Terminal port=Port1 Edges=Port1.edge(at (-17.5, -17.5, 1.6)) TerminalResistance=50ohm
  Port2_T: Terminal port=Port2 Edges=Port2.edge(at (-26.279, 17.5, 1.6)) TerminalResistance=50ohm
  Port3_T: Terminal port=Port3 Edges=Port3.edge(at (-8.72103, 17.5, 1.6)) TerminalResistance=50ohm
  Port1: Lumped Port Faces=Port1.face LumpedPortType=Terminal Impedance=50ohm
  Port2: Lumped Port Faces=Port2.face LumpedPortType=Terminal Impedance=50ohm
  Port3: Lumped Port Faces=Port3.face LumpedPortType=Terminal Impedance=50ohm
  reference conductors: Ground
setups:
  Setup1: HfssDriven Frequency=2.245GHz MaxDeltaS=0.02 MaximumPasses=20 MinimumPasses=1 MinimumConvergedPasses=1 PercentRefinement=30 BasisOrder=1 PortAccuracy=2 DrivenSolverType="Direct Solver"
    sweep Sweep: 1GHz to 3.5GHz step 10MHz; Type=Interpolating InterpTolerance=0.5 InterpMaxSolns=250 PassivityErrorTolerance=0.0001
source amplitudes:
  Port1:1: 1 0deg
  Port2:1, Port3:1: 0V 0deg
optimetrics:
  Arc_Length_Rough: Parametric Sim._Setups=[Setup1]
    sweep quarterwave_2245: 22.32mm 23.29mm 24.46mm 25.23mm 26.2mm
  W_70p7_Rough: Parametric Sim._Setups=[Setup1]
    sweep W_70p7: LIN 1.45mm 1.65mm 0.04mm
radiation setups:
  3D: Infinite Sphere Theta=0deg..180deg step 2deg Phi=-180deg..180deg step 2deg
  Elevation: Infinite Sphere Theta=-180deg..180deg step 1deg Phi=0deg..90deg step 90deg
  Azimuth: Infinite Sphere Theta=90deg..90deg step 0deg Phi=-180deg..180deg step 1deg
reports:
  Terminal S Parameter Plot2: dB(St(Port1_T,Port1_T)) vs Freq on Setup1 : Sweep [W_70p7=all quarterwave_2245=24.46mm L_Split=1mm]; markers MX1 at x=2.154e+09
  Terminal S Parameter Plot3: dB(St(Port1_T,Port1_T)), dB(St(Port2_T,Port1_T)), dB(St(Port3_T,Port1_T)), dB(St(Port1_T,Port2_T)), dB(St(Port2_T,Port2_T)), dB(St(Port3_T,Port2_T)), dB(St(Port1_T,Port3_T)), dB(St(Port2_T,Port3_T)), dB(St(Port3_T,Port3_T)) vs Freq on Setup1 : Sweep; markers MX1 at x=2.154e+09, MY1 at y=-20

design Wilkinson_V2 (HFSS, HFSS Terminal Network, model units mm)
variables:
  board_X = 70mm
  board_Y = 36mm
  board_Z = 1.6mm
  W_50 = 2.92mm  # 50 Ohm trace width
  L_Port1_Trace = 8mm  # Port 1 trace length
  W_70p7 = 1.45mm  # 70.7 Ohm trace width
  Resistor_CtoC = 0.6mm  # 0603 footprint copper to copper distance
  quarterwave_2245 = 26.96mm
  Radius = (quarterwave_2245-(Resistor_CtoC/2))/pi
  turn_radius = 5mm
  L_Split = 6mm
  offset = 3.5mm
  split_angle = 60deg  # Angle from X-axis to diagonal trace
  fillet_radius = 3mm
geometry:
  Ground = rectangle(corner=(-board_X/2, -board_Y/2, 0mm), x_size=board_X, y_size=board_Y)
  Substrate [FR4_epoxy] = box(corner=(-board_X/2, -board_Y/2, 0mm), size=(board_X, board_Y, board_Z))
  Port1_50ohms = rectangle(corner=(-(board_X/4)-(W_50/2), -board_Y/2, 1.6mm), x_size=W_50, y_size=L_Port1_Trace)
  Stub_1 = rectangle(corner=(-(board_X/4)-(Resistor_CtoC/2), -(board_Y/2)+L_Port1_Trace-(W_70p7/2), board_Z), x_size=Resistor_CtoC/2, y_size=W_70p7)
  Stub_2 = rectangle(corner=(-(board_X/4), -(board_Y/2)+L_Port1_Trace-(W_70p7/2), board_Z), x_size=Resistor_CtoC/2, y_size=W_70p7)
  Arc_1_Line = polyline((-(board_X/4)-(Resistor_CtoC/2), -(board_Y/2)+L_Port1_Trace, board_Z) (-26.286142mm, -1.5138584mm, 1.6mm) (-17.8mm, 6.9722831mm, 1.6mm), AngularArc from point 0 over 3 centre=(-(board_X/4)-(Resistor_CtoC/2), -(board_Y/2)+L_Port1_Trace+Radius, board_Z) angle=-180deg plane=XY)
  Arc_1_Line1 = polyline((-(board_X/4)+(Resistor_CtoC/2), -(board_Y/2)+L_Port1_Trace, board_Z) (-8.7138584mm, -1.5138584mm, 1.6mm) (-17.2mm, 6.9722831mm, 1.6mm), AngularArc from point 0 over 3 centre=(-(board_X/4)+(Resistor_CtoC/2), -(board_Y/2)+L_Port1_Trace+Radius, board_Z) angle=180deg plane=XY)
  Arc_1 = polyline((-(board_X/4)-(Resistor_CtoC/2), -(board_Y/2)+L_Port1_Trace-(W_70p7/2), board_Z) (-(board_X/4)-(Resistor_CtoC/2), -(board_Y/2)+L_Port1_Trace+(W_70p7/2), board_Z))
  Arc_1.sweep_along_path(Arc_1_Line)
  Arc_2 = polyline((-(board_X/4)+(Resistor_CtoC/2), -(board_Y/2)+L_Port1_Trace-(W_70p7/2), board_Z) (-(board_X/4)+(Resistor_CtoC/2), -(board_Y/2)+L_Port1_Trace+(W_70p7/2), board_Z))
  Arc_2.sweep_along_path(Arc_1_Line1)
  Resistor_100ohms = rectangle(corner=(-(board_X/4)-(Resistor_CtoC/2), -(board_Y/2)+L_Port1_Trace+2*Radius-(W_70p7 /2)+(W_70p7/4), board_Z), x_size=Resistor_CtoC, y_size=0.8mm)
  Port1 = rectangle(corner=(-(board_X/4)-(W_50/2), -board_Y/2, board_Z), z_size=-1.6mm, x_size=W_50)
  Port2 = rectangle(corner=(-(board_X/4)-(Resistor_CtoC/2)-offset-L_Split*cos(split_angle)+(W_50/2), (board_Y/2), board_Z), z_size=-1.6mm, x_size=-W_50)
  Port3 = rectangle(corner=(-(board_X/4)+(Resistor_CtoC/2)+offset+L_Split*cos(split_angle)+(W_50/2), (board_Y/2), board_Z), z_size=-1.6mm, x_size=-W_50)
  RadiatingSurface [vacuum] = region(absolute_offset=44.54343mm on all sides)
  Polyline2 = polyline((-(board_X/4)-(Resistor_CtoC/2)-offset, -(board_Y/2)+L_Port1_Trace+2*Radius-(W_70p7 /2), board_Z) (-(board_X/4)-(Resistor_CtoC/2)-offset-L_Split*cos(split_angle), -(board_Y/2)+L_Port1_Trace+2*Radius-(W_70p7 /2)+L_Split*sin(split_angle), board_Z))
  Copper_trace = polyline((-(board_X/4)-(Resistor_CtoC/2)-offset -(W_50/2)*sin(split_angle), -(board_Y/2)+L_Port1_Trace+2*Radius-(W_70p7 /2)-(W_50/2)*cos(split_angle), board_Z) (-(board_X/4)-(Resistor_CtoC/2)-offset +(W_50/2)*sin(split_angle), -(board_Y/2)+L_Port1_Trace+2*Radius-(W_70p7 /2)+(W_50/2)*cos(split_angle), board_Z))
  Polyline4 = polyline((-(board_X/4)-(Resistor_CtoC/2)-offset-L_Split*cos(split_angle), -(board_Y/2)+L_Port1_Trace+2*Radius-(W_70p7 /2)+L_Split*sin(split_angle), board_Z) (-(board_X/4)-(Resistor_CtoC/2)-offset-L_Split*cos(split_angle), (board_Y/2), board_Z))
  Polyline4.unite(Polyline2)
  Copper_trace.sweep_along_path(Polyline4)
  Copper_trace.fillet(Vertices=Copper_trace.vertex(at (-22.84, 11.8346, 1.6), at (-25.76, 11.0522, 1.6)) Radius=fillet_radius Setback=0mm)
  Polyline5 = polyline((-(board_X/4)-(Resistor_CtoC/2)-offset -(W_50/2)*sin(split_angle), -(board_Y/2)+L_Port1_Trace+2*Radius-(W_70p7 /2)-(W_50/2)*cos(split_angle), board_Z) (-(board_X/4)-(Resistor_CtoC/2)-offset +(W_50/2)*sin(split_angle), -(board_Y/2)+L_Port1_Trace+2*Radius-(W_70p7 /2)+(W_50/2)*cos(split_angle), board_Z))
  Polyline7 = polyline((-(board_X/4)-(Resistor_CtoC/2)-offset-L_Split*cos(split_angle), -(board_Y/2)+L_Port1_Trace+2*Radius-(W_70p7 /2)+L_Split*sin(split_angle), board_Z) (-(board_X/4)-(Resistor_CtoC/2)-offset-L_Split*cos(split_angle), (board_Y/2), board_Z))
  Polyline6 = polyline((-(board_X/4)-(Resistor_CtoC/2)-offset, -(board_Y/2)+L_Port1_Trace+2*Radius-(W_70p7 /2), board_Z) (-(board_X/4)-(Resistor_CtoC/2)-offset-L_Split*cos(split_angle), -(board_Y/2)+L_Port1_Trace+2*Radius-(W_70p7 /2)+L_Split*sin(split_angle), board_Z))
  Polyline7.unite(Polyline6)
  Polyline5.sweep_along_path(Polyline7)
  Polyline5.fillet(Vertices=Copper_trace.vertex(at (-22.84, 11.8346, 1.6), at (-25.76, 11.0522, 1.6)) Radius=fillet_radius Setback=0mm)
  Polyline5.mirror(point=(-17.5mm, 5.9157337mm, 1.6mm), normal=(-1mm, 0mm, 0mm))
  Copper_trace.unite(Arc_1, Polyline5, Stub_1, Arc_2, Stub_2, Port1_50ohms)
  Port1_1 = Port1.duplicate_mirror(point=(0mm, -18mm, 0mm), normal=(1mm, 0mm, 0mm))
  Port2_1 = Port2.duplicate_mirror(point=(0mm, -18mm, 0mm), normal=(1mm, 0mm, 0mm))
  Port3_1 = Port3.duplicate_mirror(point=(0mm, -18mm, 0mm), normal=(1mm, 0mm, 0mm))
  Copper_trace_1 = Copper_trace.duplicate_mirror(point=(0mm, -18mm, 1.6mm), normal=(1mm, 0mm, -5.5372719e-17mm))
  Rectangle1 = rectangle(corner=((board_X/4)-(Resistor_CtoC/2), -(board_Y/2)+L_Port1_Trace+2*Radius-(W_70p7 /2)+(W_70p7/4), board_Z), x_size=Resistor_CtoC, y_size=0.8mm)
  132357 = imported_body(C:\Users\Joshua Wong\Downloads\132357.stp)
  132357.rotate(axis=Z, angle=90deg)
  132357.rotate(axis=Y, angle=90deg)
  132357.move(0mm, -18mm, 0mm)
  132357.move(-17.5mm, 0mm, 2.220446e-15mm)
  132357.move(-2.8421709e-14mm, -0.24999998mm, 0.1000026mm)
  132357.move(0mm, 0mm, 1.6249974mm)
  132357.move(0.059999983mm, -0.15000003mm, 0.12499999mm)
  132357_1 = 132357.duplicate_mirror(point=(0mm, 0mm, 0mm), normal=(0mm, 1mm, 0mm))
  132357_1.move(-6.86mm, 0mm, 0mm)
  132357_1_1 = 132357_1.duplicate_mirror(point=(-17.5mm, 6.6097831mm, 1.6mm), normal=(1mm, 0mm, 0mm))
  132357_1_1_1 = 132357_1_1.duplicate_mirror(point=(0mm, 0mm, 0mm), normal=(1mm, 0mm, 0mm))
  132357_1_2 = 132357_1.duplicate_mirror(point=(0mm, 0mm, 0mm), normal=(1mm, 0mm, 0mm))
  132357_2 = 132357.duplicate_mirror(point=(0mm, 0mm, 0mm), normal=(1mm, 0mm, 0mm))
boundaries and excitations:
  Ground: Perfect E Objects=Ground
  LumpRLC1: Lumped RLC Objects=Resistor_100ohms CurrentLine{(-17.8, 7.0097831, 1.6) -> (-17.2, 7.0097831, 1.6)} RLC_Type=Serial Resistance=100ohm
  Open1: Radiation Objects=RadiatingSurface
  Copper_trace: Perfect E Objects=Copper_trace
  Copper_trace1: Perfect E Objects=Copper_trace_1
  LumpRLC2: Lumped RLC Objects=Rectangle1 CurrentLine{(17.8, 7.0097831, 1.6) -> (17.2, 7.0097831, 1.6)} RLC_Type=Serial Resistance=100ohm
  Port1_T: Terminal port=Port1 Edges=Port1.edge(at (-17.5, -18, 1.6)) TerminalResistance=50ohm
  Port2_T: Terminal port=Port2 Edges=Port2.edge(at (-24.3, 18, 1.6)) TerminalResistance=50ohm
  Port3_T: Terminal port=Port3 Edges=Port3.edge(at (-10.7, 18, 1.6)) TerminalResistance=50ohm
  Port4_T1: Terminal port=Port4 Edges=Port1_1.edge(at (17.5, -18, 1.6)) TerminalResistance=50ohm
  Port6_T1: Terminal port=Port6 Edges=Port2_1.edge(at (24.3, 18, 1.6)) TerminalResistance=50ohm
  Port5_T1: Terminal port=Port5 Edges=Port3_1.edge(at (10.7, 18, 1.6)) TerminalResistance=50ohm
  Port1: Lumped Port Faces=Port1.face(at (-17.5, -18, 0.8)) LumpedPortType=Terminal Impedance=50ohm
  Port2: Lumped Port Faces=Port2.face(at (-24.3, 18, 0.8)) LumpedPortType=Terminal Impedance=50ohm
  Port3: Lumped Port Faces=Port3.face(at (-10.7, 18, 0.8)) LumpedPortType=Terminal Impedance=50ohm
  Port4: Lumped Port Faces=Port1_1.face LumpedPortType=Terminal Impedance=50ohm
  Port6: Lumped Port Faces=Port2_1.face LumpedPortType=Terminal Impedance=50ohm
  Port5: Lumped Port Faces=Port3_1.face LumpedPortType=Terminal Impedance=50ohm
  reference conductors: Ground
setups:
  Setup1: HfssDriven Frequency=2.245GHz MaxDeltaS=0.02 MaximumPasses=20 MinimumPasses=1 MinimumConvergedPasses=1 PercentRefinement=30 BasisOrder=1 PortAccuracy=2 DrivenSolverType="Direct Solver"
    sweep Sweep: 1GHz to 3.5GHz step 10MHz; Type=Interpolating InterpTolerance=0.5 InterpMaxSolns=250 PassivityErrorTolerance=0.0001
source amplitudes:
  Port1:1, Port4:1: 1 0deg
  Port2:1, Port3:1, Port6:1, Port5:1: 0V 0deg
optimetrics:
  Arc_Length_Rough: Parametric Sim._Setups=[Setup1]
    sweep quarterwave_2245: LIN 24.46mm 27.5mm 0.5mm
  W_70p7_Rough: Parametric Sim._Setups=[Setup1]
    sweep W_70p7: LIN 1.29mm 1.45mm 0.04mm
  W_50_Rough: Parametric Sim._Setups=[Setup1]
    sweep W_50: LIN 2.88mm 3.04mm 0.04mm
  split_angle_Rough: Parametric Sim._Setups=[Setup1]
    sweep split_angle: LIN 57deg 63deg 1deg
radiation setups:
  3D: Infinite Sphere Theta=0deg..180deg step 2deg Phi=-180deg..180deg step 2deg
  Elevation: Infinite Sphere Theta=-180deg..180deg step 1deg Phi=0deg..90deg step 90deg
  Azimuth: Infinite Sphere Theta=90deg..90deg step 0deg Phi=-180deg..180deg step 1deg
reports:
  Terminal S Parameter Plot1: dB(St(Port1_T,Port1_T)) vs Freq on Setup1 : Sweep [W_50=all W_70p7=1.45mm quarterwave_2245=26.96mm split_angle=all]; markers MX1 at x=2.154e+09
  Terminal S Parameter Plot2: dB(St(Port1_T,Port1_T)) vs Freq on Setup1 : Sweep [W_50=2.92mm]; dB(St(Port2_T,Port1_T)), dB(St(Port3_T,Port1_T)), dB(St(Port1_T,Port2_T)), dB(St(Port2_T,Port2_T)), dB(St(Port3_T,Port2_T)), dB(St(Port1_T,Port3_T)), dB(St(Port2_T,Port3_T)), dB(St(Port3_T,Port3_T)) vs Freq on Setup1 : Sweep; markers MX1 at x=2.1538462e+09, MY1 at y=-20
  Terminal S Parameter Plot3: dB(St(Port4_T1,Port4_T1)), dB(St(Port5_T1,Port4_T1)), dB(St(Port6_T1,Port4_T1)), dB(St(Port4_T1,Port5_T1)), dB(St(Port5_T1,Port5_T1)), dB(St(Port6_T1,Port5_T1)), dB(St(Port4_T1,Port6_T1)), dB(St(Port5_T1,Port6_T1)), dB(St(Port6_T1,Port6_T1)) vs Freq on Setup1 : Sweep; markers MX1 at x=2.1538462e+09, MY1 at y=-20
  Terminal S Parameter Plot4: dB(St(Port4_T1,Port1_T)), dB(St(Port5_T1,Port3_T)), dB(St(Port1_T,Port4_T1)), dB(St(Port3_T,Port5_T1)) vs Freq on Setup1 : Sweep

design Wilkinson_V3_2067 (HFSS, HFSS Terminal Network, model units mm)
variables:
  board_X = 70mm
  board_Y = 36mm
  board_Z = 1.6mm
  W_50 = 2.92mm  # 50 Ohm trace width
  L_Port1_Trace = 8mm  # Port 1 trace length
  W_70p7 = 1.45mm  # 70.7 Ohm trace width
  Resistor_CtoC = 0.6mm  # 0603 footprint copper to copper distance
  quarterwave_2245 = 26.96mm
  Radius = (quarterwave_2245-(Resistor_CtoC/2))/pi
  turn_radius = 5mm
  L_Split = 6mm
  offset = 3.5mm
  split_angle = 60deg  # Angle from X-axis to diagonal trace
  fillet_radius = 3mm
geometry:
  Ground = rectangle(corner=(-board_X/2, -board_Y/2, 0mm), x_size=board_X, y_size=board_Y)
  Substrate [FR4_epoxy] = box(corner=(-board_X/2, -board_Y/2, 0mm), size=(board_X, board_Y, board_Z))
  Port1_50ohms = rectangle(corner=(-(board_X/4)-(W_50/2), -board_Y/2, 1.6mm), x_size=W_50, y_size=L_Port1_Trace)
  Stub_1 = rectangle(corner=(-(board_X/4)-(Resistor_CtoC/2), -(board_Y/2)+L_Port1_Trace-(W_70p7/2), board_Z), x_size=Resistor_CtoC/2, y_size=W_70p7)
  Stub_2 = rectangle(corner=(-(board_X/4), -(board_Y/2)+L_Port1_Trace-(W_70p7/2), board_Z), x_size=Resistor_CtoC/2, y_size=W_70p7)
  Arc_1_Line = polyline((-(board_X/4)-(Resistor_CtoC/2), -(board_Y/2)+L_Port1_Trace, board_Z) (-26.286142mm, -1.5138584mm, 1.6mm) (-17.8mm, 6.9722831mm, 1.6mm), AngularArc from point 0 over 3 centre=(-(board_X/4)-(Resistor_CtoC/2), -(board_Y/2)+L_Port1_Trace+Radius, board_Z) angle=-180deg plane=XY)
  Arc_1_Line1 = polyline((-(board_X/4)+(Resistor_CtoC/2), -(board_Y/2)+L_Port1_Trace, board_Z) (-8.7138584mm, -1.5138584mm, 1.6mm) (-17.2mm, 6.9722831mm, 1.6mm), AngularArc from point 0 over 3 centre=(-(board_X/4)+(Resistor_CtoC/2), -(board_Y/2)+L_Port1_Trace+Radius, board_Z) angle=180deg plane=XY)
  Arc_1 = polyline((-(board_X/4)-(Resistor_CtoC/2), -(board_Y/2)+L_Port1_Trace-(W_70p7/2), board_Z) (-(board_X/4)-(Resistor_CtoC/2), -(board_Y/2)+L_Port1_Trace+(W_70p7/2), board_Z))
  Arc_1.sweep_along_path(Arc_1_Line)
  Arc_2 = polyline((-(board_X/4)+(Resistor_CtoC/2), -(board_Y/2)+L_Port1_Trace-(W_70p7/2), board_Z) (-(board_X/4)+(Resistor_CtoC/2), -(board_Y/2)+L_Port1_Trace+(W_70p7/2), board_Z))
  Arc_2.sweep_along_path(Arc_1_Line1)
  Resistor_100ohms = rectangle(corner=(-(board_X/4)-(Resistor_CtoC/2), -(board_Y/2)+L_Port1_Trace+2*Radius-(W_70p7 /2)+(W_70p7/4), board_Z), x_size=Resistor_CtoC, y_size=0.8mm)
  Port1 = rectangle(corner=(-(board_X/4)-(W_50/2), -board_Y/2, board_Z), z_size=-1.6mm, x_size=W_50)
  Port2 = rectangle(corner=(-(board_X/4)-(Resistor_CtoC/2)-offset-L_Split*cos(split_angle)+(W_50/2), (board_Y/2), board_Z), z_size=-1.6mm, x_size=-W_50)
  Port3 = rectangle(corner=(-(board_X/4)+(Resistor_CtoC/2)+offset+L_Split*cos(split_angle)+(W_50/2), (board_Y/2), board_Z), z_size=-1.6mm, x_size=-W_50)
  RadiatingSurface [vacuum] = region(absolute_offset=44.54343mm on all sides)
  Polyline2 = polyline((-(board_X/4)-(Resistor_CtoC/2)-offset, -(board_Y/2)+L_Port1_Trace+2*Radius-(W_70p7 /2), board_Z) (-(board_X/4)-(Resistor_CtoC/2)-offset-L_Split*cos(split_angle), -(board_Y/2)+L_Port1_Trace+2*Radius-(W_70p7 /2)+L_Split*sin(split_angle), board_Z))
  Copper_trace = polyline((-(board_X/4)-(Resistor_CtoC/2)-offset -(W_50/2)*sin(split_angle), -(board_Y/2)+L_Port1_Trace+2*Radius-(W_70p7 /2)-(W_50/2)*cos(split_angle), board_Z) (-(board_X/4)-(Resistor_CtoC/2)-offset +(W_50/2)*sin(split_angle), -(board_Y/2)+L_Port1_Trace+2*Radius-(W_70p7 /2)+(W_50/2)*cos(split_angle), board_Z))
  Polyline4 = polyline((-(board_X/4)-(Resistor_CtoC/2)-offset-L_Split*cos(split_angle), -(board_Y/2)+L_Port1_Trace+2*Radius-(W_70p7 /2)+L_Split*sin(split_angle), board_Z) (-(board_X/4)-(Resistor_CtoC/2)-offset-L_Split*cos(split_angle), (board_Y/2), board_Z))
  Polyline4.unite(Polyline2)
  Copper_trace.sweep_along_path(Polyline4)
  Copper_trace.fillet(Vertices=Copper_trace.vertex(at (-22.84, 11.8346, 1.6), at (-25.76, 11.0522, 1.6)) Radius=fillet_radius Setback=0mm)
  Polyline5 = polyline((-(board_X/4)-(Resistor_CtoC/2)-offset -(W_50/2)*sin(split_angle), -(board_Y/2)+L_Port1_Trace+2*Radius-(W_70p7 /2)-(W_50/2)*cos(split_angle), board_Z) (-(board_X/4)-(Resistor_CtoC/2)-offset +(W_50/2)*sin(split_angle), -(board_Y/2)+L_Port1_Trace+2*Radius-(W_70p7 /2)+(W_50/2)*cos(split_angle), board_Z))
  Polyline7 = polyline((-(board_X/4)-(Resistor_CtoC/2)-offset-L_Split*cos(split_angle), -(board_Y/2)+L_Port1_Trace+2*Radius-(W_70p7 /2)+L_Split*sin(split_angle), board_Z) (-(board_X/4)-(Resistor_CtoC/2)-offset-L_Split*cos(split_angle), (board_Y/2), board_Z))
  Polyline6 = polyline((-(board_X/4)-(Resistor_CtoC/2)-offset, -(board_Y/2)+L_Port1_Trace+2*Radius-(W_70p7 /2), board_Z) (-(board_X/4)-(Resistor_CtoC/2)-offset-L_Split*cos(split_angle), -(board_Y/2)+L_Port1_Trace+2*Radius-(W_70p7 /2)+L_Split*sin(split_angle), board_Z))
  Polyline7.unite(Polyline6)
  Polyline5.sweep_along_path(Polyline7)
  Polyline5.fillet(Vertices=Copper_trace.vertex(at (-22.84, 11.8346, 1.6), at (-25.76, 11.0522, 1.6)) Radius=fillet_radius Setback=0mm)
  Polyline5.mirror(point=(-17.5mm, 5.9157337mm, 1.6mm), normal=(-1mm, 0mm, 0mm))
  Copper_trace.unite(Arc_1, Polyline5, Stub_1, Arc_2, Stub_2, Port1_50ohms)
boundaries and excitations:
  Ground: Perfect E Objects=Ground
  LumpRLC1: Lumped RLC Objects=Resistor_100ohms CurrentLine{(-17.8, 7.0097831, 1.6) -> (-17.2, 7.0097831, 1.6)} RLC_Type=Serial Resistance=100ohm
  Open1: Radiation Objects=RadiatingSurface
  Copper_trace: Perfect E Objects=Copper_trace
  Port1_T: Terminal port=Port1 Edges=Port1.edge(at (-17.5, -18, 1.6)) TerminalResistance=50ohm
  Port2_T: Terminal port=Port2 Edges=Port2.edge(at (-24.3, 18, 1.6)) TerminalResistance=50ohm
  Port3_T: Terminal port=Port3 Edges=Port3.edge(at (-10.7, 18, 1.6)) TerminalResistance=50ohm
  Port1: Lumped Port Faces=Port1.face LumpedPortType=Terminal Impedance=50ohm
  Port2: Lumped Port Faces=Port2.face LumpedPortType=Terminal Impedance=50ohm
  Port3: Lumped Port Faces=Port3.face LumpedPortType=Terminal Impedance=50ohm
  reference conductors: Ground
setups:
  Setup1: HfssDriven Frequency=2.245GHz MaxDeltaS=0.02 MaximumPasses=20 MinimumPasses=1 MinimumConvergedPasses=1 PercentRefinement=30 BasisOrder=1 PortAccuracy=2 DrivenSolverType="Direct Solver"
    sweep Sweep: 1GHz to 3.5GHz step 10MHz; Type=Interpolating InterpTolerance=0.5 InterpMaxSolns=250 PassivityErrorTolerance=0.0001
source amplitudes:
  Port1:1: 1 0deg
  Port2:1, Port3:1: 0V 0deg
optimetrics:
  Arc_Length_Rough: Parametric Sim._Setups=[Setup1]
    sweep quarterwave_2245: LIN 24.46mm 27.5mm 0.5mm
  W_70p7_Rough: Parametric Sim._Setups=[Setup1]
    sweep W_70p7: LIN 1.29mm 1.45mm 0.04mm
  W_50_Rough: Parametric Sim._Setups=[Setup1]
    sweep W_50: LIN 2.88mm 3.04mm 0.04mm
  split_angle_Rough: Parametric Sim._Setups=[Setup1]
    sweep split_angle: LIN 57deg 63deg 1deg
radiation setups:
  3D: Infinite Sphere Theta=0deg..180deg step 2deg Phi=-180deg..180deg step 2deg
  Elevation: Infinite Sphere Theta=-180deg..180deg step 1deg Phi=0deg..90deg step 90deg
  Azimuth: Infinite Sphere Theta=90deg..90deg step 0deg Phi=-180deg..180deg step 1deg
reports:
  Terminal S Parameter Plot1: dB(St(Port1_T,Port1_T)) vs Freq on Setup1 : Sweep [W_50=all W_70p7=1.45mm quarterwave_2245=26.96mm split_angle=all]; markers MX1 at x=2.154e+09
  Terminal S Parameter Plot2: dB(St(Port1_T,Port1_T)) vs Freq on Setup1 : Sweep [W_50=2.92mm]; dB(St(Port2_T,Port1_T)), dB(St(Port3_T,Port1_T)), dB(St(Port1_T,Port2_T)), dB(St(Port2_T,Port2_T)), dB(St(Port3_T,Port2_T)), dB(St(Port1_T,Port3_T)), dB(St(Port2_T,Port3_T)), dB(St(Port3_T,Port3_T)) vs Freq on Setup1 : Sweep; markers MX1 at x=2.1538462e+09, MY1 at y=-20
  Terminal S Parameter Plot3: dB(St(Port4_T1,Port4_T1)), dB(St(Port5_T1,Port4_T1)), dB(St(Port6_T1,Port4_T1)), dB(St(Port4_T1,Port5_T1)), dB(St(Port5_T1,Port5_T1)), dB(St(Port6_T1,Port5_T1)), dB(St(Port4_T1,Port6_T1)), dB(St(Port5_T1,Port6_T1)), dB(St(Port6_T1,Port6_T1)) vs Freq on Setup1 : Sweep; markers MX1 at x=2.1538462e+09, MY1 at y=-20
  Terminal S Parameter Plot4: dB(St(Port4_T1,Port1_T)), dB(St(Port5_T1,Port3_T)), dB(St(Port1_T,Port4_T1)), dB(St(Port3_T,Port5_T1)) vs Freq on Setup1 : Sweep

design Wilkinson_V3_2245 (HFSS, HFSS Terminal Network, model units mm)
variables:
  board_X = 70mm
  board_Y = 36mm
  board_Z = 1.6mm
  W_50 = 2.92mm  # 50 Ohm trace width
  L_Port1_Trace = 8mm  # Port 1 trace length
  W_70p7 = 1.45mm  # 70.7 Ohm trace width
  Resistor_CtoC = 0.6mm  # 0603 footprint copper to copper distance
  quarterwave_2245 = 26.96mm
  Radius = (quarterwave_2245-(Resistor_CtoC/2))/pi
  turn_radius = 5mm
  L_Split = 6mm
  offset = 3.5mm
  split_angle = 60deg  # Angle from X-axis to diagonal trace
  fillet_radius = 3mm
geometry:
  Ground = rectangle(corner=(-board_X/2, -board_Y/2, 0mm), x_size=board_X, y_size=board_Y)
  Substrate [FR4_epoxy] = box(corner=(-board_X/2, -board_Y/2, 0mm), size=(board_X, board_Y, board_Z))
  Port1_50ohms = rectangle(corner=(-(board_X/4)-(W_50/2), -board_Y/2, 1.6mm), x_size=W_50, y_size=L_Port1_Trace)
  Stub_1 = rectangle(corner=(-(board_X/4)-(Resistor_CtoC/2), -(board_Y/2)+L_Port1_Trace-(W_70p7/2), board_Z), x_size=Resistor_CtoC/2, y_size=W_70p7)
  Stub_2 = rectangle(corner=(-(board_X/4), -(board_Y/2)+L_Port1_Trace-(W_70p7/2), board_Z), x_size=Resistor_CtoC/2, y_size=W_70p7)
  Arc_1_Line = polyline((-(board_X/4)-(Resistor_CtoC/2), -(board_Y/2)+L_Port1_Trace, board_Z) (-26.286142mm, -1.5138584mm, 1.6mm) (-17.8mm, 6.9722831mm, 1.6mm), AngularArc from point 0 over 3 centre=(-(board_X/4)-(Resistor_CtoC/2), -(board_Y/2)+L_Port1_Trace+Radius, board_Z) angle=-180deg plane=XY)
  Arc_1_Line1 = polyline((-(board_X/4)+(Resistor_CtoC/2), -(board_Y/2)+L_Port1_Trace, board_Z) (-8.7138584mm, -1.5138584mm, 1.6mm) (-17.2mm, 6.9722831mm, 1.6mm), AngularArc from point 0 over 3 centre=(-(board_X/4)+(Resistor_CtoC/2), -(board_Y/2)+L_Port1_Trace+Radius, board_Z) angle=180deg plane=XY)
  Arc_1 = polyline((-(board_X/4)-(Resistor_CtoC/2), -(board_Y/2)+L_Port1_Trace-(W_70p7/2), board_Z) (-(board_X/4)-(Resistor_CtoC/2), -(board_Y/2)+L_Port1_Trace+(W_70p7/2), board_Z))
  Arc_1.sweep_along_path(Arc_1_Line)
  Arc_2 = polyline((-(board_X/4)+(Resistor_CtoC/2), -(board_Y/2)+L_Port1_Trace-(W_70p7/2), board_Z) (-(board_X/4)+(Resistor_CtoC/2), -(board_Y/2)+L_Port1_Trace+(W_70p7/2), board_Z))
  Arc_2.sweep_along_path(Arc_1_Line1)
  Resistor_100ohms = rectangle(corner=(-(board_X/4)-(Resistor_CtoC/2), -(board_Y/2)+L_Port1_Trace+2*Radius-(W_70p7 /2)+(W_70p7/4), board_Z), x_size=Resistor_CtoC, y_size=0.8mm)
  Port1 = rectangle(corner=(-(board_X/4)-(W_50/2), -board_Y/2, board_Z), z_size=-1.6mm, x_size=W_50)
  Port2 = rectangle(corner=(-(board_X/4)-(Resistor_CtoC/2)-offset-L_Split*cos(split_angle)+(W_50/2), (board_Y/2), board_Z), z_size=-1.6mm, x_size=-W_50)
  Port3 = rectangle(corner=(-(board_X/4)+(Resistor_CtoC/2)+offset+L_Split*cos(split_angle)+(W_50/2), (board_Y/2), board_Z), z_size=-1.6mm, x_size=-W_50)
  RadiatingSurface [vacuum] = region(absolute_offset=44.54343mm on all sides)
  Polyline2 = polyline((-(board_X/4)-(Resistor_CtoC/2)-offset, -(board_Y/2)+L_Port1_Trace+2*Radius-(W_70p7 /2), board_Z) (-(board_X/4)-(Resistor_CtoC/2)-offset-L_Split*cos(split_angle), -(board_Y/2)+L_Port1_Trace+2*Radius-(W_70p7 /2)+L_Split*sin(split_angle), board_Z))
  Copper_trace = polyline((-(board_X/4)-(Resistor_CtoC/2)-offset -(W_50/2)*sin(split_angle), -(board_Y/2)+L_Port1_Trace+2*Radius-(W_70p7 /2)-(W_50/2)*cos(split_angle), board_Z) (-(board_X/4)-(Resistor_CtoC/2)-offset +(W_50/2)*sin(split_angle), -(board_Y/2)+L_Port1_Trace+2*Radius-(W_70p7 /2)+(W_50/2)*cos(split_angle), board_Z))
  Polyline4 = polyline((-(board_X/4)-(Resistor_CtoC/2)-offset-L_Split*cos(split_angle), -(board_Y/2)+L_Port1_Trace+2*Radius-(W_70p7 /2)+L_Split*sin(split_angle), board_Z) (-(board_X/4)-(Resistor_CtoC/2)-offset-L_Split*cos(split_angle), (board_Y/2), board_Z))
  Polyline4.unite(Polyline2)
  Copper_trace.sweep_along_path(Polyline4)
  Copper_trace.fillet(Vertices=Copper_trace.vertex(at (-22.84, 11.8346, 1.6), at (-25.76, 11.0522, 1.6)) Radius=fillet_radius Setback=0mm)
  Polyline5 = polyline((-(board_X/4)-(Resistor_CtoC/2)-offset -(W_50/2)*sin(split_angle), -(board_Y/2)+L_Port1_Trace+2*Radius-(W_70p7 /2)-(W_50/2)*cos(split_angle), board_Z) (-(board_X/4)-(Resistor_CtoC/2)-offset +(W_50/2)*sin(split_angle), -(board_Y/2)+L_Port1_Trace+2*Radius-(W_70p7 /2)+(W_50/2)*cos(split_angle), board_Z))
  Polyline7 = polyline((-(board_X/4)-(Resistor_CtoC/2)-offset-L_Split*cos(split_angle), -(board_Y/2)+L_Port1_Trace+2*Radius-(W_70p7 /2)+L_Split*sin(split_angle), board_Z) (-(board_X/4)-(Resistor_CtoC/2)-offset-L_Split*cos(split_angle), (board_Y/2), board_Z))
  Polyline6 = polyline((-(board_X/4)-(Resistor_CtoC/2)-offset, -(board_Y/2)+L_Port1_Trace+2*Radius-(W_70p7 /2), board_Z) (-(board_X/4)-(Resistor_CtoC/2)-offset-L_Split*cos(split_angle), -(board_Y/2)+L_Port1_Trace+2*Radius-(W_70p7 /2)+L_Split*sin(split_angle), board_Z))
  Polyline7.unite(Polyline6)
  Polyline5.sweep_along_path(Polyline7)
  Polyline5.fillet(Vertices=Copper_trace.vertex(at (-22.84, 11.8346, 1.6), at (-25.76, 11.0522, 1.6)) Radius=fillet_radius Setback=0mm)
  Polyline5.mirror(point=(-17.5mm, 5.9157337mm, 1.6mm), normal=(-1mm, 0mm, 0mm))
  Copper_trace.unite(Arc_1, Polyline5, Stub_1, Arc_2, Stub_2, Port1_50ohms)
boundaries and excitations:
  Ground: Perfect E Objects=Ground
  LumpRLC1: Lumped RLC Objects=Resistor_100ohms CurrentLine{(-17.8, 7.0097831, 1.6) -> (-17.2, 7.0097831, 1.6)} RLC_Type=Serial Resistance=100ohm
  Open1: Radiation Objects=RadiatingSurface
  Copper_trace: Perfect E Objects=Copper_trace
  Port1_T: Terminal port=Port1 Edges=Port1.edge(at (-17.5, -18, 1.6)) TerminalResistance=50ohm
  Port2_T: Terminal port=Port2 Edges=Port2.edge(at (-24.3, 18, 1.6)) TerminalResistance=50ohm
  Port3_T: Terminal port=Port3 Edges=Port3.edge(at (-10.7, 18, 1.6)) TerminalResistance=50ohm
  Port1: Lumped Port Faces=Port1.face LumpedPortType=Terminal Impedance=50ohm
  Port2: Lumped Port Faces=Port2.face LumpedPortType=Terminal Impedance=50ohm
  Port3: Lumped Port Faces=Port3.face LumpedPortType=Terminal Impedance=50ohm
  reference conductors: Ground
setups:
  Setup1: HfssDriven Frequency=2.245GHz MaxDeltaS=0.02 MaximumPasses=20 MinimumPasses=1 MinimumConvergedPasses=1 PercentRefinement=30 BasisOrder=1 PortAccuracy=2 DrivenSolverType="Direct Solver"
    sweep Sweep: 1GHz to 3.5GHz step 10MHz; Type=Interpolating InterpTolerance=0.5 InterpMaxSolns=250 PassivityErrorTolerance=0.0001
source amplitudes:
  Port1:1: 1 0deg
  Port2:1, Port3:1: 0V 0deg
optimetrics:
  Arc_Length_Rough: Parametric Sim._Setups=[Setup1]
    sweep quarterwave_2245: LIN 24.46mm 27.5mm 0.5mm
  W_70p7_Rough: Parametric Sim._Setups=[Setup1]
    sweep W_70p7: LIN 1.29mm 1.45mm 0.04mm
  W_50_Rough: Parametric Sim._Setups=[Setup1]
    sweep W_50: LIN 2.88mm 3.04mm 0.04mm
  split_angle_Rough: Parametric Sim._Setups=[Setup1]
    sweep split_angle: LIN 57deg 63deg 1deg
radiation setups:
  3D: Infinite Sphere Theta=0deg..180deg step 2deg Phi=-180deg..180deg step 2deg
  Elevation: Infinite Sphere Theta=-180deg..180deg step 1deg Phi=0deg..90deg step 90deg
  Azimuth: Infinite Sphere Theta=90deg..90deg step 0deg Phi=-180deg..180deg step 1deg
reports:
  Terminal S Parameter Plot1: dB(St(Port1_T,Port1_T)) vs Freq on Setup1 : Sweep [W_50=all W_70p7=1.45mm quarterwave_2245=26.96mm split_angle=all]; markers MX1 at x=2.154e+09
  Terminal S Parameter Plot2: dB(St(Port1_T,Port1_T)) vs Freq on Setup1 : Sweep [W_50=2.92mm]; dB(St(Port2_T,Port1_T)), dB(St(Port3_T,Port1_T)), dB(St(Port1_T,Port2_T)), dB(St(Port2_T,Port2_T)), dB(St(Port3_T,Port2_T)), dB(St(Port1_T,Port3_T)), dB(St(Port2_T,Port3_T)), dB(St(Port3_T,Port3_T)) vs Freq on Setup1 : Sweep; markers MX1 at x=2.1538462e+09, MY1 at y=-20
  Terminal S Parameter Plot3: dB(St(Port4_T1,Port4_T1)), dB(St(Port5_T1,Port4_T1)), dB(St(Port6_T1,Port4_T1)), dB(St(Port4_T1,Port5_T1)), dB(St(Port5_T1,Port5_T1)), dB(St(Port6_T1,Port5_T1)), dB(St(Port4_T1,Port6_T1)), dB(St(Port5_T1,Port6_T1)), dB(St(Port6_T1,Port6_T1)) vs Freq on Setup1 : Sweep; markers MX1 at x=2.1538462e+09, MY1 at y=-20
  Terminal S Parameter Plot4: dB(St(Port4_T1,Port1_T)), dB(St(Port5_T1,Port3_T)), dB(St(Port1_T,Port4_T1)), dB(St(Port3_T,Port5_T1)) vs Freq on Setup1 : Sweep

design Wilkinson_V3 (HFSS, HFSS Terminal Network, model units mm)
variables:
  board_X = 70mm
  board_Y = 36mm
  board_Z = 1.6mm
  W_50 = 2.92mm  # 50 Ohm trace width
  L_Port1_Trace = 8mm  # Port 1 trace length
  W_70p7 = 1.45mm  # 70.7 Ohm trace width
  Resistor_CtoC = 0.6mm  # 0603 footprint copper to copper distance
  quarterwave_2245 = 26.4mm
  Radius = (quarterwave_2245-(Resistor_CtoC/2))/pi
  turn_radius = 5mm
  L_Split = 6mm
  offset = 3.5mm
  split_angle = 60deg  # Angle from X-axis to diagonal trace
  fillet_radius = 3mm
  W_50_2067 = 2.92mm
  L_Port1_Trace_2067 = 8mm
  W_70p7_2067 = 1.45mm
  quarterwave_2067 = 28.3mm
  Radius_2067 = (quarterwave_2067-(Resistor_CtoC/2))/pi
  L_split_2067 = 6mm
  offset_2067 = 3.5mm
  split_angle_2067 = 60deg
  copper_thickness = 0.035mm
  er_FR4 = 4.5
geometry:
  Ground [copper] = rectangle(corner=(-board_X/2, -board_Y/2, 0mm), x_size=board_X, y_size=board_Y)
  Substrate [FR4_epoxy_Wilkinson] = box(corner=(-board_X/2, -board_Y/2, 0mm), size=(board_X, board_Y, board_Z))
  Port1_50ohms = rectangle(corner=(-(board_X/4)-(W_50/2), -board_Y/2, 1.6mm), x_size=W_50, y_size=L_Port1_Trace)
  Stub_1 = rectangle(corner=(-(board_X/4)-(Resistor_CtoC/2), -(board_Y/2)+L_Port1_Trace-(W_70p7/2), board_Z), x_size=Resistor_CtoC/2, y_size=W_70p7)
  Stub_2 = rectangle(corner=(-(board_X/4), -(board_Y/2)+L_Port1_Trace-(W_70p7/2), board_Z), x_size=Resistor_CtoC/2, y_size=W_70p7)
  Arc_1_Line = polyline((-(board_X/4)-(Resistor_CtoC/2), -(board_Y/2)+L_Port1_Trace, board_Z) (-26.107888mm, -1.692112mm, 1.6mm) (-17.8mm, 6.6157761mm, 1.6mm), AngularArc from point 0 over 3 centre=(-(board_X/4)-(Resistor_CtoC/2), -(board_Y/2)+L_Port1_Trace+Radius, board_Z) angle=-180deg plane=XY)
  Arc_1_Line1 = polyline((-(board_X/4)+(Resistor_CtoC/2), -(board_Y/2)+L_Port1_Trace, board_Z) (-8.892112mm, -1.692112mm, 1.6mm) (-17.2mm, 6.6157761mm, 1.6mm), AngularArc from point 0 over 3 centre=(-(board_X/4)+(Resistor_CtoC/2), -(board_Y/2)+L_Port1_Trace+Radius, board_Z) angle=180deg plane=XY)
  Arc_1 = polyline((-(board_X/4)-(Resistor_CtoC/2), -(board_Y/2)+L_Port1_Trace-(W_70p7/2), board_Z) (-(board_X/4)-(Resistor_CtoC/2), -(board_Y/2)+L_Port1_Trace+(W_70p7/2), board_Z))
  Arc_1.sweep_along_path(Arc_1_Line)
  Arc_2 = polyline((-(board_X/4)+(Resistor_CtoC/2), -(board_Y/2)+L_Port1_Trace-(W_70p7/2), board_Z) (-(board_X/4)+(Resistor_CtoC/2), -(board_Y/2)+L_Port1_Trace+(W_70p7/2), board_Z))
  Arc_2.sweep_along_path(Arc_1_Line1)
  Resistor_100ohms = rectangle(corner=(-(board_X/4)-(Resistor_CtoC/2), -(board_Y/2)+L_Port1_Trace+2*Radius-(W_70p7 /2)+(W_70p7/4), board_Z), x_size=Resistor_CtoC, y_size=0.8mm)
  Port1 = rectangle(corner=(-(board_X/4)-(W_50/2), -board_Y/2, board_Z), z_size=-1.6mm, x_size=W_50)
  Port2 = rectangle(corner=(-(board_X/4)-(Resistor_CtoC/2)-offset-L_Split*cos(split_angle)+(W_50/2), (board_Y/2), board_Z), z_size=-1.6mm, x_size=-W_50)
  Port3 = rectangle(corner=(-(board_X/4)+(Resistor_CtoC/2)+offset+L_Split*cos(split_angle)+(W_50/2), (board_Y/2), board_Z), z_size=-1.6mm, x_size=-W_50)
  RadiatingSurface [vacuum] = region(absolute_offset=44.54343mm on all sides)
  Polyline2 = polyline((-(board_X/4)-(Resistor_CtoC/2)-offset, -(board_Y/2)+L_Port1_Trace+2*Radius-(W_70p7 /2), board_Z) (-(board_X/4)-(Resistor_CtoC/2)-offset-L_Split*cos(split_angle), -(board_Y/2)+L_Port1_Trace+2*Radius-(W_70p7 /2)+L_Split*sin(split_angle), board_Z))
  Copper_trace [copper] = polyline((-(board_X/4)-(Resistor_CtoC/2)-offset -(W_50/2)*sin(split_angle), -(board_Y/2)+L_Port1_Trace+2*Radius-(W_70p7 /2)-(W_50/2)*cos(split_angle), board_Z) (-(board_X/4)-(Resistor_CtoC/2)-offset +(W_50/2)*sin(split_angle), -(board_Y/2)+L_Port1_Trace+2*Radius-(W_70p7 /2)+(W_50/2)*cos(split_angle), board_Z))
  Polyline4 = polyline((-(board_X/4)-(Resistor_CtoC/2)-offset-L_Split*cos(split_angle), -(board_Y/2)+L_Port1_Trace+2*Radius-(W_70p7 /2)+L_Split*sin(split_angle), board_Z) (-(board_X/4)-(Resistor_CtoC/2)-offset-L_Split*cos(split_angle), (board_Y/2), board_Z))
  Polyline4.unite(Polyline2)
  Copper_trace.sweep_along_path(Polyline4)
  Copper_trace.fillet(Vertices=Copper_trace.vertex(at (-22.84, 11.4781, 1.6), at (-25.76, 10.6957, 1.6)) Radius=fillet_radius Setback=0mm)
  Polyline5 = polyline((-(board_X/4)-(Resistor_CtoC/2)-offset -(W_50/2)*sin(split_angle), -(board_Y/2)+L_Port1_Trace+2*Radius-(W_70p7 /2)-(W_50/2)*cos(split_angle), board_Z) (-(board_X/4)-(Resistor_CtoC/2)-offset +(W_50/2)*sin(split_angle), -(board_Y/2)+L_Port1_Trace+2*Radius-(W_70p7 /2)+(W_50/2)*cos(split_angle), board_Z))
  Polyline7 = polyline((-(board_X/4)-(Resistor_CtoC/2)-offset-L_Split*cos(split_angle), -(board_Y/2)+L_Port1_Trace+2*Radius-(W_70p7 /2)+L_Split*sin(split_angle), board_Z) (-(board_X/4)-(Resistor_CtoC/2)-offset-L_Split*cos(split_angle), (board_Y/2), board_Z))
  Polyline6 = polyline((-(board_X/4)-(Resistor_CtoC/2)-offset, -(board_Y/2)+L_Port1_Trace+2*Radius-(W_70p7 /2), board_Z) (-(board_X/4)-(Resistor_CtoC/2)-offset-L_Split*cos(split_angle), -(board_Y/2)+L_Port1_Trace+2*Radius-(W_70p7 /2)+L_Split*sin(split_angle), board_Z))
  Polyline7.unite(Polyline6)
  Polyline5.sweep_along_path(Polyline7)
  Polyline5.fillet(Vertices=Copper_trace.vertex(at (-22.84, 11.4781, 1.6), at (-25.76, 10.6957, 1.6)) Radius=fillet_radius Setback=0mm)
  Polyline5.mirror(point=(-17.5mm, 5.9157337mm, 1.6mm), normal=(-1mm, 0mm, 0mm))
  Copper_trace.unite(Arc_1, Polyline5, Stub_1, Arc_2, Stub_2, Port1_50ohms)
  Copper_trace1 [copper] = polyline((-(board_X/4)-(Resistor_CtoC/2)-offset_2067 -(W_50_2067/2)*sin(split_angle_2067), -(board_Y/2)+L_Port1_Trace_2067+2*Radius_2067-(W_70p7_2067 /2)-(W_50_2067/2)*cos(split_angle_2067), board_Z) (-(board_X/4)-(Resistor_CtoC/2)-offset_2067 +(W_50_2067/2)*sin(split_angle_2067), -(board_Y/2)+L_Port1_Trace_2067+2*Radius_2067-(W_70p7_2067 /2)+(W_50_2067/2)*cos(split_angle_2067), board_Z))
  Polyline9 = polyline((-(board_X/4)-(Resistor_CtoC/2)-offset_2067-L_Split_2067*cos(split_angle_2067), -(board_Y/2)+L_Port1_Trace_2067+2*Radius_2067-(W_70p7_2067 /2)+L_Split_2067*sin(split_angle_2067), board_Z) (-(board_X/4)-(Resistor_CtoC/2)-offset_2067-L_Split_2067*cos(split_angle_2067), (board_Y/2), board_Z))
  Polyline8 = polyline((-(board_X/4)-(Resistor_CtoC/2)-offset_2067, -(board_Y/2)+L_Port1_Trace_2067+2*Radius_2067-(W_70p7_2067 /2), board_Z) (-(board_X/4)-(Resistor_CtoC/2)-offset_2067-L_Split_2067*cos(split_angle_2067), -(board_Y/2)+L_Port1_Trace_2067+2*Radius_2067-(W_70p7_2067 /2)+L_Split_2067*sin(split_angle_2067), board_Z))
  Polyline9.unite(Polyline8)
  Copper_trace1.sweep_along_path(Polyline9)
  Copper_trace1.fillet(Vertices=Copper_trace1.vertex(at (-22.84, 12.6877, 1.6), at (-25.76, 11.9053, 1.6)) Radius=fillet_radius Setback=0mm)
  Arc_3 = polyline((-(board_X/4)-(Resistor_CtoC/2), -(board_Y/2)+L_Port1_Trace_2067-(W_70p7_2067/2), board_Z) (-(board_X/4)-(Resistor_CtoC/2), -(board_Y/2)+L_Port1_Trace_2067+(W_70p7_2067/2), board_Z))
  Arc_1_Line2 = polyline((-(board_X/4)-(Resistor_CtoC/2), -(board_Y/2)+L_Port1_Trace_2067, board_Z) (-26.712677mm, -1.0873232mm, 1.6mm) (-17.8mm, 7.8253536mm, 1.6mm), AngularArc from point 0 over 3 centre=(-(board_X/4)-(Resistor_CtoC/2), -(board_Y/2)+L_Port1_Trace_2067+Radius_2067, board_Z) angle=-180deg plane=XY)
  Arc_3.sweep_along_path(Arc_1_Line2)
  Polyline10 = polyline((-(board_X/4)-(Resistor_CtoC/2)-offset_2067 -(W_50_2067/2)*sin(split_angle_2067), -(board_Y/2)+L_Port1_Trace_2067+2*Radius_2067-(W_70p7_2067/2)-(W_50_2067/2)*cos(split_angle_2067), board_Z) (-(board_X/4)-(Resistor_CtoC/2)-offset_2067 +(W_50_2067/2)*sin(split_angle_2067), -(board_Y/2)+L_Port1_Trace_2067+2*Radius_2067-(W_70p7_2067/2)+(W_50_2067/2)*cos(split_angle_2067), board_Z))
  Polyline12 = polyline((-(board_X/4)-(Resistor_CtoC/2)-offset_2067-L_Split_2067*cos(split_angle_2067), -(board_Y/2)+L_Port1_Trace_2067+2*Radius_2067-(W_70p7_2067/2)+L_Split_2067*sin(split_angle_2067), board_Z) (-(board_X/4)-(Resistor_CtoC/2)-offset_2067-L_Split_2067*cos(split_angle_2067), (board_Y/2), board_Z))
  Polyline11 = polyline((-(board_X/4)-(Resistor_CtoC/2)-offset_2067, -(board_Y/2)+L_Port1_Trace_2067+2*Radius_2067-(W_70p7_2067 /2), board_Z) (-(board_X/4)-(Resistor_CtoC/2)-offset_2067-L_Split_2067*cos(split_angle_2067), -(board_Y/2)+L_Port1_Trace_2067+2*Radius_2067-(W_70p7_2067 /2)+L_Split_2067*sin(split_angle_2067), board_Z))
  Polyline12.unite(Polyline11)
  Polyline10.sweep_along_path(Polyline12)
  Polyline10.fillet(Vertices=Copper_trace1.vertex(at (-22.84, 12.6877, 1.6), at (-25.76, 11.9053, 1.6)) Radius=fillet_radius Setback=0mm)
  Polyline10.mirror(point=(-17.5mm, 5.9157337mm, 1.6mm), normal=(-1mm, 0mm, 0mm))
  Stub_3 = rectangle(corner=(-(board_X/4)-(Resistor_CtoC/2), -(board_Y/2)+L_Port1_Trace_2067-(W_70p7_2067/2), board_Z), x_size=Resistor_CtoC/2, y_size=W_70p7_2067)
  Arc_4 = polyline((-(board_X/4)+(Resistor_CtoC/2), -(board_Y/2)+L_Port1_Trace_2067-(W_70p7_2067/2), board_Z) (-(board_X/4)+(Resistor_CtoC/2), -(board_Y/2)+L_Port1_Trace_2067+(W_70p7_2067/2), board_Z))
  Arc_1_Line3 = polyline((-(board_X/4)+(Resistor_CtoC/2), -(board_Y/2)+L_Port1_Trace_2067, board_Z) (-8.2873232mm, -1.0873232mm, 1.6mm) (-17.2mm, 7.8253536mm, 1.6mm), AngularArc from point 0 over 3 centre=(-(board_X/4)+(Resistor_CtoC/2), -(board_Y/2)+L_Port1_Trace_2067+Radius_2067, board_Z) angle=180deg plane=XY)
  Arc_4.sweep_along_path(Arc_1_Line3)
  Stub_4 = rectangle(corner=(-(board_X/4), -(board_Y/2)+L_Port1_Trace_2067-(W_70p7_2067/2), board_Z), x_size=Resistor_CtoC/2, y_size=W_70p7_2067)
  Port1_50ohms1 = rectangle(corner=(-(board_X/4)-(W_50_2067/2), -board_Y/2, board_Z), x_size=W_50_2067, y_size=L_Port1_Trace_2067)
  Copper_trace1.unite(Arc_3, Polyline10, Stub_3, Arc_4, Stub_4, Port1_50ohms1)
  Copper_trace1.mirror(point=(0mm, 0mm, 0mm), normal=(1mm, 0mm, 0mm))
  Port4 = rectangle(corner=(-(board_X/4)-(W_50_2067/2), -board_Y/2, board_Z), z_size=-1.6mm, x_size=W_50_2067)
  Port5 = rectangle(corner=(-(board_X/4)-(Resistor_CtoC/2)-offset_2067-L_split_2067*cos(split_angle_2067)+(W_50_2067/2), (board_Y/2), board_Z), z_size=-1.6mm, x_size=-W_50_2067)
  Port6 = rectangle(corner=(-(board_X/4)+(Resistor_CtoC/2)+offset_2067+L_split_2067*cos(split_angle_2067)+(W_50_2067/2), (board_Y/2), board_Z), z_size=-1.6mm, x_size=-W_50_2067)
  [Port4, Port5, Port6].mirror(point=(0mm, 0mm, 0mm), normal=(1mm, 0mm, 0mm))
  Resistor_100ohms_2067 = rectangle(corner=((board_X/4)-(Resistor_CtoC/2), -(board_Y/2)+L_Port1_Trace_2067+2*Radius_2067-(W_70p7_2067/2)+(W_70p7_2067/4), board_Z), x_size=Resistor_CtoC, y_size=0.8mm)
  [Copper_trace, Copper_trace1].thicken(copper_thickness)
  Ground.thicken(-copper_thickness)
boundaries and excitations:
  Ground: Perfect E Objects=Ground
  LumpRLC1: Lumped RLC Objects=Resistor_100ohms CurrentLine{(-17.8, 6.6532761, 1.6) -> (-17.2, 6.6532761, 1.6)} RLC_Type=Serial Resistance=100ohm
  Open1: Radiation Objects=RadiatingSurface
  Copper_trace: Perfect E Objects=Copper_trace
  Copper_trace1: Perfect E Objects=Copper_trace1
  LumpRLC2: Lumped RLC Objects=Resistor_100ohms_2067 CurrentLine{(17.2, 7.8628536, 1.6) -> (17.8, 7.8628536, 1.6)} RLC_Type=Serial Resistance=100ohm
  Port1_T: Terminal port=Port1 Edges=Port1.edge(at (-17.5, -18, 1.6)) TerminalResistance=50ohm
  Port2_T: Terminal port=Port2 Edges=Port2.edge(at (-24.3, 18, 1.6)) TerminalResistance=50ohm
  Port3_T: Terminal port=Port3 Edges=Port3.edge(at (-10.7, 18, 1.6)) TerminalResistance=50ohm
  Port4_T: Terminal port=Port4 Edges=Port4.edge(at (17.5, -18, 1.6)) TerminalResistance=50ohm
  Port5_T: Terminal port=Port5 Edges=Port5.edge(at (24.3, 18, 1.6)) TerminalResistance=50ohm
  Port6_T: Terminal port=Port6 Edges=Port6.edge(at (10.7, 18, 1.6)) TerminalResistance=50ohm
  Port1: Lumped Port Faces=Port1.face LumpedPortType=Terminal Impedance=50ohm
  Port2: Lumped Port Faces=Port2.face LumpedPortType=Terminal Impedance=50ohm
  Port3: Lumped Port Faces=Port3.face LumpedPortType=Terminal Impedance=50ohm
  Port4: Lumped Port Faces=Port4.face(at (17.5, -18, 0.8)) LumpedPortType=Terminal Impedance=50ohm
  Port5: Lumped Port Faces=Port5.face(at (24.3, 18, 0.8)) LumpedPortType=Terminal Impedance=50ohm
  Port6: Lumped Port Faces=Port6.face(at (10.7, 18, 0.8)) LumpedPortType=Terminal Impedance=50ohm
  reference conductors: Ground
setups:
  2245: HfssDriven Frequency=2.245GHz MaxDeltaS=0.02 MaximumPasses=20 MinimumPasses=1 MinimumConvergedPasses=1 PercentRefinement=30 disabled BasisOrder=1 PortAccuracy=2 DrivenSolverType="Direct Solver"
    sweep Sweep: 1GHz to 3.5GHz step 10MHz; Type=Interpolating InterpTolerance=0.5 InterpMaxSolns=250 PassivityErrorTolerance=0.0001
  2067: HfssDriven Frequency=2.067GHz MaxDeltaS=0.02 MaximumPasses=20 MinimumPasses=1 MinimumConvergedPasses=1 PercentRefinement=30 disabled BasisOrder=1 PortAccuracy=2 DrivenSolverType="Direct Solver"
    sweep Sweep: 1GHz to 3.5GHz step 10MHz; Type=Interpolating InterpTolerance=0.5 InterpMaxSolns=250 PassivityErrorTolerance=0.0001
  both_frequencies: HfssDriven MultipleAdaptiveFreqsSetup{AdaptAt{Frequency=2.067GHz Delta=0.015} AdaptAt{Frequency=2.245GHz Delta=0.015}} MaximumPasses=20 MinimumPasses=1 MinimumConvergedPasses=1 PercentRefinement=30 BasisOrder=1 PortAccuracy=2 DrivenSolverType="Direct Solver"
    sweep Sweep: 1GHz to 3.5GHz step 10MHz; Type=Interpolating InterpTolerance=0.5 InterpMaxSolns=250 PassivityErrorTolerance=0.0001
source amplitudes:
  Port1:1, Port4:1: 1 0deg
  Port2:1, Port3:1, Port5:1, Port6:1: 0V 0deg
optimetrics:
  quarterwave_2245_sweep: Parametric Sim._Setups=[both_frequencies]
    sweep quarterwave_2245: LIN 26.3mm 26.5mm 0.1mm
  quarterwave_2067_sweep: Parametric Sim._Setups=[both_frequencies]
    sweep quarterwave_2067: LIN 28mm 29mm 0.2mm
  W_50_sweep: Parametric Sim._Setups=[both_frequencies]
    sweep W_50: LIN 2.8mm 3mm 0.05mm
  er_FR4_sweep: Parametric Sim._Setups=[both_frequencies]
    sweep $er_FR4: 4.1 4.4 4.8
radiation setups:
  3D: Infinite Sphere Theta=0deg..180deg step 2deg Phi=-180deg..180deg step 2deg
  Elevation: Infinite Sphere Theta=-180deg..180deg step 1deg Phi=0deg..90deg step 90deg
  Azimuth: Infinite Sphere Theta=90deg..90deg step 0deg Phi=-180deg..180deg step 1deg
reports:
  Terminal S Parameter Plot1: dB(St(Port1_T,Port1_T)), dB(St(Port2_T,Port1_T)), dB(St(Port3_T,Port1_T)), dB(St(Port1_T,Port2_T)), dB(St(Port2_T,Port2_T)), dB(St(Port3_T,Port2_T)), dB(St(Port1_T,Port3_T)), dB(St(Port2_T,Port3_T)), dB(St(Port3_T,Port3_T)) vs Freq on both_frequencies : Sweep; markers MX1 at x=2.245e+09
  Terminal S Parameter Plot2: dB(St(Port4_T,Port4_T)), dB(St(Port5_T,Port4_T)), dB(St(Port6_T,Port4_T)), dB(St(Port4_T,Port5_T)), dB(St(Port5_T,Port5_T)), dB(St(Port6_T,Port5_T)), dB(St(Port4_T,Port6_T)), dB(St(Port5_T,Port6_T)), dB(St(Port6_T,Port6_T)) vs Freq on both_frequencies : Sweep; markers MX1 at x=2.067e+09
  Phase (2245): ang_deg(St(Port2_T,Port1_T)), ang_deg(St(Port3_T,Port1_T)), ang_deg(St(Port2_T,Port1_T)/St(Port3_T,Port1_T)) vs Freq on both_frequencies : Sweep; markers MX1 at x=2.245e+09
  Phase (2067): ang_deg(St(Port5_T,Port4_T)), ang_deg(St(Port6_T,Port4_T)), ang_deg(St(Port5_T,Port4_T)/St(Port6_T,Port4_T)) vs Freq on both_frequencies : Sweep; markers MX1 at x=2.0672515e+09
  Terminal S Parameter Plot3: dB(St(Port1_T,Port1_T)) vs Freq on both_frequencies : Sweep [$er_FR4=all]; markers MX1 at x=2.2454068e+09
  Terminal S Parameter Plot4: dB(St(Port4_T,Port4_T)) vs Freq on both_frequencies : Sweep [$er_FR4=all]; markers MX1 at x=2.0674157e+09
  Terminal S Parameter Plot5: dB(St(Port1_T,Port1_T)), dB(St(Port2_T,Port1_T)), dB(St(Port3_T,Port1_T)), dB(St(Port1_T,Port2_T)), dB(St(Port2_T,Port2_T)), dB(St(Port3_T,Port2_T)), dB(St(Port1_T,Port3_T)), dB(St(Port2_T,Port3_T)), dB(St(Port3_T,Port3_T)) vs Freq on both_frequencies : Sweep [W_50=2.92mm quarterwave_2245=26.4mm quarterwave_2067=28.3mm $er_FR4=4.4]; markers m1 at 2.27GHz, MX1 at x=2.2447479e+09
  Terminal S Parameter Plot6: dB(St(Port4_T,Port4_T)), dB(St(Port5_T,Port4_T)), dB(St(Port6_T,Port4_T)), dB(St(Port4_T,Port5_T)), dB(St(Port5_T,Port5_T)), dB(St(Port6_T,Port5_T)), dB(St(Port4_T,Port6_T)), dB(St(Port5_T,Port6_T)), dB(St(Port6_T,Port6_T)) vs Freq on both_frequencies : Sweep; markers m1 at 2.09GHz, MX1 at x=2.0666488e+09

design Wilkinson_V4 (HFSS, HFSS Terminal Network, model units mm)
variables:
  board_X = 70mm
  board_Y = 36mm
  board_Z = 1.6mm
  W_50 = 2.92mm  # 50 Ohm trace width
  L_Port1_Trace = 8mm  # Port 1 trace length
  W_70p7 = 1.45mm  # 70.7 Ohm trace width
  Resistor_CtoC = 0.35mm  # 0603 footprint copper to copper distance
  quarterwave_2245 = 26.4mm
  Radius = (quarterwave_2245-(Resistor_CtoC/2))/pi
  turn_radius = 5mm
  L_Split = 6mm
  offset = 3.5mm
  split_angle = 60deg  # Angle from X-axis to diagonal trace
  fillet_radius = 3mm
  W_50_2067 = 2.92mm
  L_Port1_Trace_2067 = 8mm
  W_70p7_2067 = 1.45mm
  quarterwave_2067 = 28.3mm
  Radius_2067 = (quarterwave_2067-(Resistor_CtoC/2))/pi
  L_split_2067 = 6mm
  offset_2067 = 3.5mm
  split_angle_2067 = 60deg
  copper_thickness = 0.035mm
  er_FR4 = 4.5
  SMA_Pad_W = 2mm
  SMA_Pad_H = 4.9mm
  SMA_Pad_Separation = 8.5mm
  Resistor_Height = 0.5mm
  Via_Radius = 0.15mm
  Via_edge_spacing = 0.5mm
  Via_center_spacing = 1.3mm
geometry:
  Ground [copper] = rectangle(corner=(-board_X/2, -board_Y/2, 0mm), x_size=board_X, y_size=board_Y)
  Substrate [FR4_epoxy_Wilkinson] = box(corner=(-board_X/2, -board_Y/2, 0mm), size=(board_X, board_Y, board_Z))
  Port1_50ohms = rectangle(corner=(-(board_X/4)-(W_50/2), -board_Y/2, 1.6mm), x_size=W_50, y_size=L_Port1_Trace)
  Stub_1 = rectangle(corner=(-(board_X/4)-(Resistor_CtoC/2), -(board_Y/2)+L_Port1_Trace-(W_70p7/2), board_Z), x_size=Resistor_CtoC/2, y_size=W_70p7)
  Stub_2 = rectangle(corner=(-(board_X/4), -(board_Y/2)+L_Port1_Trace-(W_70p7/2), board_Z), x_size=Resistor_CtoC/2, y_size=W_70p7)
  Arc_1_Line = polyline((-(board_X/4)-(Resistor_CtoC/2), -(board_Y/2)+L_Port1_Trace, board_Z) (-26.022677mm, -1.6523232mm, 1.6mm) (-17.675mm, 6.6953535mm, 1.6mm), AngularArc from point 0 over 3 centre=(-(board_X/4)-(Resistor_CtoC/2), -(board_Y/2)+L_Port1_Trace+Radius, board_Z) angle=-180deg plane=XY)
  Arc_1_Line1 = polyline((-(board_X/4)+(Resistor_CtoC/2), -(board_Y/2)+L_Port1_Trace, board_Z) (-8.9773232mm, -1.6523232mm, 1.6mm) (-17.325mm, 6.6953535mm, 1.6mm), AngularArc from point 0 over 3 centre=(-(board_X/4)+(Resistor_CtoC/2), -(board_Y/2)+L_Port1_Trace+Radius, board_Z) angle=180deg plane=XY)
  Arc_1 = polyline((-(board_X/4)-(Resistor_CtoC/2), -(board_Y/2)+L_Port1_Trace-(W_70p7/2), board_Z) (-(board_X/4)-(Resistor_CtoC/2), -(board_Y/2)+L_Port1_Trace+(W_70p7/2), board_Z))
  Arc_1.sweep_along_path(Arc_1_Line)
  Arc_2 = polyline((-(board_X/4)+(Resistor_CtoC/2), -(board_Y/2)+L_Port1_Trace-(W_70p7/2), board_Z) (-(board_X/4)+(Resistor_CtoC/2), -(board_Y/2)+L_Port1_Trace+(W_70p7/2), board_Z))
  Arc_2.sweep_along_path(Arc_1_Line1)
  Resistor_100ohms = rectangle(corner=(-(board_X/4)-(Resistor_CtoC/2), -(board_Y/2)+L_Port1_Trace+2*Radius-(W_70p7 /2)+(W_70p7/4), board_Z), x_size=Resistor_CtoC, y_size=Resistor_Height)
  RadiatingSurface [vacuum] = region(absolute_offset=44.54343mm on all sides)
  Polyline2 = polyline((-(board_X/4)-(Resistor_CtoC/2)-offset, -(board_Y/2)+L_Port1_Trace+2*Radius-(W_70p7 /2), board_Z) (-(board_X/4)-(Resistor_CtoC/2)-offset-L_Split*cos(split_angle), -(board_Y/2)+L_Port1_Trace+2*Radius-(W_70p7 /2)+L_Split*sin(split_angle), board_Z))
  Copper_trace_2245 [copper] = polyline((-(board_X/4)-(Resistor_CtoC/2)-offset -(W_50/2)*sin(split_angle), -(board_Y/2)+L_Port1_Trace+2*Radius-(W_70p7 /2)-(W_50/2)*cos(split_angle), board_Z) (-(board_X/4)-(Resistor_CtoC/2)-offset +(W_50/2)*sin(split_angle), -(board_Y/2)+L_Port1_Trace+2*Radius-(W_70p7 /2)+(W_50/2)*cos(split_angle), board_Z))
  Polyline4 = polyline((-(board_X/4)-(Resistor_CtoC/2)-offset-L_Split*cos(split_angle), -(board_Y/2)+L_Port1_Trace+2*Radius-(W_70p7 /2)+L_Split*sin(split_angle), board_Z) (-(board_X/4)-(Resistor_CtoC/2)-offset-L_Split*cos(split_angle), (board_Y/2), board_Z))
  Polyline4.unite(Polyline2)
  Copper_trace_2245.sweep_along_path(Polyline4)
  Copper_trace_2245.fillet(Vertices=Copper_trace_2245.vertex(at (-22.715, 11.5577, 1.6), at (-25.635, 10.7753, 1.6)) Radius=fillet_radius Setback=0mm)
  Polyline5 = polyline((-(board_X/4)-(Resistor_CtoC/2)-offset -(W_50/2)*sin(split_angle), -(board_Y/2)+L_Port1_Trace+2*Radius-(W_70p7 /2)-(W_50/2)*cos(split_angle), board_Z) (-(board_X/4)-(Resistor_CtoC/2)-offset +(W_50/2)*sin(split_angle), -(board_Y/2)+L_Port1_Trace+2*Radius-(W_70p7 /2)+(W_50/2)*cos(split_angle), board_Z))
  Polyline7 = polyline((-(board_X/4)-(Resistor_CtoC/2)-offset-L_Split*cos(split_angle), -(board_Y/2)+L_Port1_Trace+2*Radius-(W_70p7 /2)+L_Split*sin(split_angle), board_Z) (-(board_X/4)-(Resistor_CtoC/2)-offset-L_Split*cos(split_angle), (board_Y/2), board_Z))
  Polyline6 = polyline((-(board_X/4)-(Resistor_CtoC/2)-offset, -(board_Y/2)+L_Port1_Trace+2*Radius-(W_70p7 /2), board_Z) (-(board_X/4)-(Resistor_CtoC/2)-offset-L_Split*cos(split_angle), -(board_Y/2)+L_Port1_Trace+2*Radius-(W_70p7 /2)+L_Split*sin(split_angle), board_Z))
  Polyline7.unite(Polyline6)
  Polyline5.sweep_along_path(Polyline7)
  Polyline5.fillet(Vertices=Copper_trace_2245.vertex(at (-22.715, 11.5577, 1.6), at (-25.635, 10.7753, 1.6)) Radius=fillet_radius Setback=0mm)
  Polyline5.mirror(point=(-17.5mm, 5.9157337mm, 1.6mm), normal=(-1mm, 0mm, 0mm))
  Copper_trace_2245.unite(Arc_1, Polyline5, Stub_1, Arc_2, Stub_2, Port1_50ohms)
  Copper_trace_2067 [copper] = polyline((-(board_X/4)-(Resistor_CtoC/2)-offset_2067 -(W_50_2067/2)*sin(split_angle_2067), -(board_Y/2)+L_Port1_Trace_2067+2*Radius_2067-(W_70p7_2067 /2)-(W_50_2067/2)*cos(split_angle_2067), board_Z) (-(board_X/4)-(Resistor_CtoC/2)-offset_2067 +(W_50_2067/2)*sin(split_angle_2067), -(board_Y/2)+L_Port1_Trace_2067+2*Radius_2067-(W_70p7_2067 /2)+(W_50_2067/2)*cos(split_angle_2067), board_Z))
  Polyline9 = polyline((-(board_X/4)-(Resistor_CtoC/2)-offset_2067-L_Split_2067*cos(split_angle_2067), -(board_Y/2)+L_Port1_Trace_2067+2*Radius_2067-(W_70p7_2067 /2)+L_Split_2067*sin(split_angle_2067), board_Z) (-(board_X/4)-(Resistor_CtoC/2)-offset_2067-L_Split_2067*cos(split_angle_2067), (board_Y/2), board_Z))
  Polyline8 = polyline((-(board_X/4)-(Resistor_CtoC/2)-offset_2067, -(board_Y/2)+L_Port1_Trace_2067+2*Radius_2067-(W_70p7_2067 /2), board_Z) (-(board_X/4)-(Resistor_CtoC/2)-offset_2067-L_Split_2067*cos(split_angle_2067), -(board_Y/2)+L_Port1_Trace_2067+2*Radius_2067-(W_70p7_2067 /2)+L_Split_2067*sin(split_angle_2067), board_Z))
  Polyline9.unite(Polyline8)
  Copper_trace_2067.sweep_along_path(Polyline9)
  Copper_trace_2067.fillet(Vertices=Copper_trace_2067.vertex(at (-22.715, 12.7673, 1.6), at (-25.635, 11.9849, 1.6)) Radius=fillet_radius Setback=0mm)
  Arc_3 = polyline((-(board_X/4)-(Resistor_CtoC/2), -(board_Y/2)+L_Port1_Trace_2067-(W_70p7_2067/2), board_Z) (-(board_X/4)-(Resistor_CtoC/2), -(board_Y/2)+L_Port1_Trace_2067+(W_70p7_2067/2), board_Z))
  Arc_1_Line2 = polyline((-(board_X/4)-(Resistor_CtoC/2), -(board_Y/2)+L_Port1_Trace_2067, board_Z) (-26.627466mm, -1.0475345mm, 1.6mm) (-17.675mm, 7.9049311mm, 1.6mm), AngularArc from point 0 over 3 centre=(-(board_X/4)-(Resistor_CtoC/2), -(board_Y/2)+L_Port1_Trace_2067+Radius_2067, board_Z) angle=-180deg plane=XY)
  Arc_3.sweep_along_path(Arc_1_Line2)
  Polyline10 = polyline((-(board_X/4)-(Resistor_CtoC/2)-offset_2067 -(W_50_2067/2)*sin(split_angle_2067), -(board_Y/2)+L_Port1_Trace_2067+2*Radius_2067-(W_70p7_2067/2)-(W_50_2067/2)*cos(split_angle_2067), board_Z) (-(board_X/4)-(Resistor_CtoC/2)-offset_2067 +(W_50_2067/2)*sin(split_angle_2067), -(board_Y/2)+L_Port1_Trace_2067+2*Radius_2067-(W_70p7_2067/2)+(W_50_2067/2)*cos(split_angle_2067), board_Z))
  Polyline12 = polyline((-(board_X/4)-(Resistor_CtoC/2)-offset_2067-L_Split_2067*cos(split_angle_2067), -(board_Y/2)+L_Port1_Trace_2067+2*Radius_2067-(W_70p7_2067/2)+L_Split_2067*sin(split_angle_2067), board_Z) (-(board_X/4)-(Resistor_CtoC/2)-offset_2067-L_Split_2067*cos(split_angle_2067), (board_Y/2), board_Z))
  Polyline11 = polyline((-(board_X/4)-(Resistor_CtoC/2)-offset_2067, -(board_Y/2)+L_Port1_Trace_2067+2*Radius_2067-(W_70p7_2067 /2), board_Z) (-(board_X/4)-(Resistor_CtoC/2)-offset_2067-L_Split_2067*cos(split_angle_2067), -(board_Y/2)+L_Port1_Trace_2067+2*Radius_2067-(W_70p7_2067 /2)+L_Split_2067*sin(split_angle_2067), board_Z))
  Polyline12.unite(Polyline11)
  Polyline10.sweep_along_path(Polyline12)
  Polyline10.fillet(Vertices=Copper_trace_2067.vertex(at (-22.715, 12.7673, 1.6), at (-25.635, 11.9849, 1.6)) Radius=fillet_radius Setback=0mm)
  Polyline10.mirror(point=(-17.5mm, 5.9157337mm, 1.6mm), normal=(-1mm, 0mm, 0mm))
  Stub_3 = rectangle(corner=(-(board_X/4)-(Resistor_CtoC/2), -(board_Y/2)+L_Port1_Trace_2067-(W_70p7_2067/2), board_Z), x_size=Resistor_CtoC/2, y_size=W_70p7_2067)
  Arc_4 = polyline((-(board_X/4)+(Resistor_CtoC/2), -(board_Y/2)+L_Port1_Trace_2067-(W_70p7_2067/2), board_Z) (-(board_X/4)+(Resistor_CtoC/2), -(board_Y/2)+L_Port1_Trace_2067+(W_70p7_2067/2), board_Z))
  Arc_1_Line3 = polyline((-(board_X/4)+(Resistor_CtoC/2), -(board_Y/2)+L_Port1_Trace_2067, board_Z) (-8.3725345mm, -1.0475345mm, 1.6mm) (-17.325mm, 7.9049311mm, 1.6mm), AngularArc from point 0 over 3 centre=(-(board_X/4)+(Resistor_CtoC/2), -(board_Y/2)+L_Port1_Trace_2067+Radius_2067, board_Z) angle=180deg plane=XY)
  Arc_4.sweep_along_path(Arc_1_Line3)
  Stub_4 = rectangle(corner=(-(board_X/4), -(board_Y/2)+L_Port1_Trace_2067-(W_70p7_2067/2), board_Z), x_size=Resistor_CtoC/2, y_size=W_70p7_2067)
  Port1_50ohms1 = rectangle(corner=(-(board_X/4)-(W_50_2067/2), -board_Y/2, board_Z), x_size=W_50_2067, y_size=L_Port1_Trace_2067)
  Copper_trace_2067.unite(Arc_3, Polyline10, Stub_3, Arc_4, Stub_4, Port1_50ohms1)
  Copper_trace_2067.mirror(point=(0mm, 0mm, 0mm), normal=(1mm, 0mm, 0mm))
  Resistor_100ohms_2067 = rectangle(corner=((board_X/4)-(Resistor_CtoC/2), -(board_Y/2)+L_Port1_Trace_2067+2*Radius_2067-(W_70p7_2067/2)+(W_70p7_2067/4), board_Z), x_size=Resistor_CtoC, y_size=Resistor_Height)
  [Copper_trace_2245, Copper_trace_2067].thicken(copper_thickness)
  Ground.thicken(-copper_thickness)
  13235711 = imported_body(C:\Users\Joshua Wong\Downloads\132357-11.stp)
  13235711.rotate(axis=Z, angle=90deg)
  13235711.rotate(axis=Y, angle=90deg)
  13235711.move(0mm, -40mm, 0mm)
  Cylinder1 = cylinder(axis=Y, base_centre=(0mm, -47.49mm, 0mm), radius=2.05mm, height=7mm)
  SMA_Dielectric [Teflon (tm)] = cylinder(axis=Y, base_centre=(0mm, -47.49mm, 0mm), radius=2.05mm, height=7mm)
  13235711.subtract(Cylinder1)
  13235711_ObjectFromFace1 = object_from(SMA_Probe.face(at (0, -40.49, 0)))
  SMA_Probe [copper] = sweep_along_normal(13235711_ObjectFromFace1.face, length=7mm)
  13235711_ObjectFromFace1.delete()
  SMA_Probe.unite(13235711)
  13235711_ObjectFromFace1_SweepFaceAlongNormal1_1 = SMA_Probe.copy()
  SMA_Dielectric.subtract(13235711_ObjectFromFace1_SweepFaceAlongNormal1_1)
  SMA_Body [brass] = SMA_Probe.separate_bodies()
  Pad1 = rectangle(corner=(-(board_X/4)-(SMA_Pad_Separation/2)-(SMA_Pad_W/2), -board_Y/2, board_Z), x_size=SMA_Pad_W, y_size=SMA_Pad_H)
  Pad1.thicken(copper_thickness)
  Pad2 = Pad1.duplicate_mirror(point=(-board_X/4, -18mm, 1.635mm), normal=(-1mm, 0mm, 0mm))
  Vias_Pad1 = cylinder(axis=Z, base_centre=(-(board_X/4)-(SMA_Pad_Separation/2), -board_Y/2+Via_edge_spacing, 0), radius=Via_Radius, height=board_Z)
  Vias_Pad1.duplicate_along_line(step=(0mm, Via_center_spacing, 0mm), total=4, attached)
  Vias_Pad2 = Vias_Pad1.duplicate_mirror(point=(-board_X/4, -18mm, 1.635mm), normal=(1mm, 0mm, 0mm))
  [SMA_Dielectric, SMA_Probe, SMA_Body].move(-board_X/4, 40mm-board_Y/2, 1.76mm)
  SMA_Dielectric1 [Teflon (tm)] = cylinder(axis=Y, base_centre=(0mm, -47.49mm, 0mm), radius=2.05mm, height=7mm)
  13235712 = imported_body(C:\Users\Joshua Wong\Downloads\132357-11.stp)
  13235712.rotate(axis=Z, angle=90deg)
  13235712.rotate(axis=Y, angle=90deg)
  13235712.move(0mm, -40mm, 0mm)
  Cylinder2 = cylinder(axis=Y, base_centre=(0mm, -47.49mm, 0mm), radius=2.05mm, height=7mm)
  13235712.subtract(Cylinder2)
  13235711_ObjectFromFace2 = object_from(SMA_Probe1.face(at (0, -40.49, 0)))
  SMA_Probe1 [copper] = sweep_along_normal(13235711_ObjectFromFace2.face, length=7mm)
  SMA_Probe1.unite(13235712)
  13235711_ObjectFromFace1_SweepFaceAlongNormal1_2 = SMA_Probe1.copy()
  SMA_Dielectric1.subtract(13235711_ObjectFromFace1_SweepFaceAlongNormal1_2)
  13235711_ObjectFromFace2.delete()
  SMA_Dielectric1.move(-board_X/4, 40mm-board_Y/2, 1.76mm)
  SMA_Body1 [brass] = SMA_Probe1.separate_bodies()
  [SMA_Probe1, SMA_Body1].move(-board_X/4, 40mm-board_Y/2, 1.76mm)
  Pad3 = rectangle(corner=(-(board_X/4)-(SMA_Pad_Separation/2)-(SMA_Pad_W/2), -board_Y/2, board_Z), x_size=SMA_Pad_W, y_size=SMA_Pad_H)
  Pad3.thicken(copper_thickness)
  Pad4 = Pad3.duplicate_mirror(point=(-board_X/4, -18mm, 1.635mm), normal=(-1mm, 0mm, 0mm))
  Vias_Pad3 = cylinder(axis=Z, base_centre=(-(board_X/4)-(SMA_Pad_Separation/2), -board_Y/2+Via_edge_spacing, 0), radius=Via_Radius, height=board_Z)
  Vias_Pad3.duplicate_along_line(step=(0mm, Via_center_spacing, 0mm), total=4, attached)
  Vias_Pad4 = Vias_Pad3.duplicate_mirror(point=(-board_X/4, -18mm, 1.635mm), normal=(1mm, 0mm, 0mm))
  [SMA_Dielectric1, SMA_Probe1, SMA_Body1, Pad3, Pad4, Vias_Pad3, Vias_Pad4].mirror(point=(0mm, 0mm, 0mm), normal=(0mm, 1mm, 0mm))
  [SMA_Dielectric1, SMA_Probe1, SMA_Body1, Pad3, Pad4, Vias_Pad3, Vias_Pad4].move(-(Resistor_CtoC/2)-offset-L_Split*cos(split_angle), 0mm, 0mm)
  SMA_Dielectric2 [Teflon (tm)] = cylinder(axis=Y, base_centre=(0mm, -47.49mm, 0mm), radius=2.05mm, height=7mm)
  13235713 = imported_body(C:\Users\Joshua Wong\Downloads\132357-11.stp)
  13235713.rotate(axis=Z, angle=90deg)
  13235713.rotate(axis=Y, angle=90deg)
  13235713.move(0mm, -40mm, 0mm)
  Cylinder3 = cylinder(axis=Y, base_centre=(0mm, -47.49mm, 0mm), radius=2.05mm, height=7mm)
  13235713.subtract(Cylinder3)
  13235711_ObjectFromFace3 = object_from(SMA_Probe2.face(at (0, -40.49, 0)))
  SMA_Probe2 [copper] = sweep_along_normal(13235711_ObjectFromFace3.face, length=7mm)
  SMA_Probe2.unite(13235713)
  13235711_ObjectFromFace1_SweepFaceAlongNormal1_3 = SMA_Probe2.copy()
  SMA_Dielectric2.subtract(13235711_ObjectFromFace1_SweepFaceAlongNormal1_3)
  13235711_ObjectFromFace3.delete()
  SMA_Dielectric2.move(-board_X/4, 40mm-board_Y/2, 1.76mm)
  SMA_Dielectric2.mirror(point=(0mm, 0mm, 0mm), normal=(0mm, 1mm, 0mm))
  SMA_Dielectric2.move(-(Resistor_CtoC/2)-offset-L_Split*cos(split_angle), 0mm, 0mm)
  SMA_Body2 [brass] = SMA_Probe2.separate_bodies()
  SMA_Probe2.move(-board_X/4, 40mm-board_Y/2, 1.76mm)
  SMA_Probe2.mirror(point=(0mm, 0mm, 0mm), normal=(0mm, 1mm, 0mm))
  SMA_Probe2.move(-(Resistor_CtoC/2)-offset-L_Split*cos(split_angle), 0mm, 0mm)
  SMA_Body2.move(-board_X/4, 40mm-board_Y/2, 1.76mm)
  SMA_Body2.mirror(point=(0mm, 0mm, 0mm), normal=(0mm, 1mm, 0mm))
  SMA_Body2.move(-(Resistor_CtoC/2)-offset-L_Split*cos(split_angle), 0mm, 0mm)
  Pad5 = rectangle(corner=(-(board_X/4)-(SMA_Pad_Separation/2)-(SMA_Pad_W/2), -board_Y/2, board_Z), x_size=SMA_Pad_W, y_size=SMA_Pad_H)
  Pad5.thicken(copper_thickness)
  Pad6 = Pad5.duplicate_mirror(point=(-board_X/4, -18mm, 1.635mm), normal=(-1mm, 0mm, 0mm))
  Pad5.mirror(point=(0mm, 0mm, 0mm), normal=(0mm, 1mm, 0mm))
  Pad5.move(-(Resistor_CtoC/2)-offset-L_Split*cos(split_angle), 0mm, 0mm)
  Pad6.mirror(point=(0mm, 0mm, 0mm), normal=(0mm, 1mm, 0mm))
  Pad6.move(-(Resistor_CtoC/2)-offset-L_Split*cos(split_angle), 0mm, 0mm)
  Vias_Pad5 = cylinder(axis=Z, base_centre=(-(board_X/4)-(SMA_Pad_Separation/2), -board_Y/2+Via_edge_spacing, 0), radius=Via_Radius, height=board_Z)
  Vias_Pad5.duplicate_along_line(step=(0mm, Via_center_spacing, 0mm), total=4, attached)
  Vias_Pad6 = Vias_Pad5.duplicate_mirror(point=(-board_X/4, -18mm, 1.635mm), normal=(1mm, 0mm, 0mm))
  Vias_Pad5.mirror(point=(0mm, 0mm, 0mm), normal=(0mm, 1mm, 0mm))
  Vias_Pad5.move(-(Resistor_CtoC/2)-offset-L_Split*cos(split_angle), 0mm, 0mm)
  Vias_Pad6.mirror(point=(0mm, 0mm, 0mm), normal=(0mm, 1mm, 0mm))
  Vias_Pad6.move(-(Resistor_CtoC/2)-offset-L_Split*cos(split_angle), 0mm, 0mm)
  SMA_Dielectric2.mirror(point=(-17.5mm, 0mm, 0mm), normal=(1mm, 0mm, 0mm))
  [SMA_Probe2, SMA_Body2, Pad5, Pad6, Vias_Pad5, Vias_Pad6].mirror(point=(-board_X/4, 0mm, 0mm), normal=(1mm, 0mm, 0mm))
  SMA_Dielectric3 [Teflon (tm)] = cylinder(axis=Y, base_centre=(0mm, -47.49mm, 0mm), radius=2.05mm, height=7mm)
  13235714 = imported_body(C:\Users\Joshua Wong\Downloads\132357-11.stp)
  13235714.rotate(axis=Z, angle=90deg)
  13235714.rotate(axis=Y, angle=90deg)
  13235714.move(0mm, -40mm, 0mm)
  Cylinder4 = cylinder(axis=Y, base_centre=(0mm, -47.49mm, 0mm), radius=2.05mm, height=7mm)
  13235714.subtract(Cylinder4)
  13235711_ObjectFromFace4 = object_from(SMA_Probe3.face(at (0, -40.49, 0)))
  SMA_Probe3 [copper] = sweep_along_normal(13235711_ObjectFromFace4.face, length=7mm)
  SMA_Probe3.unite(13235714)
  13235711_ObjectFromFace1_SweepFaceAlongNormal1_4 = SMA_Probe3.copy()
  SMA_Dielectric3.subtract(13235711_ObjectFromFace1_SweepFaceAlongNormal1_4)
  13235711_ObjectFromFace4.delete()
  SMA_Dielectric3.move(-board_X/4, 40mm-board_Y/2, 1.76mm)
  SMA_Body3 [brass] = SMA_Probe3.separate_bodies()
  [SMA_Probe3, SMA_Body3].move(-board_X/4, 40mm-board_Y/2, 1.76mm)
  Pad7 = rectangle(corner=(-(board_X/4)-(SMA_Pad_Separation/2)-(SMA_Pad_W/2), -board_Y/2, board_Z), x_size=SMA_Pad_W, y_size=SMA_Pad_H)
  Pad7.thicken(copper_thickness)
  Pad8 = Pad7.duplicate_mirror(point=(-board_X/4, -18mm, 1.635mm), normal=(-1mm, 0mm, 0mm))
  Vias_Pad7 = cylinder(axis=Z, base_centre=(-(board_X/4)-(SMA_Pad_Separation/2), -board_Y/2+Via_edge_spacing, 0), radius=Via_Radius, height=board_Z)
  Vias_Pad7.duplicate_along_line(step=(0mm, Via_center_spacing, 0mm), total=4, attached)
  Vias_Pad8 = Vias_Pad7.duplicate_mirror(point=(-board_X/4, -18mm, 1.635mm), normal=(1mm, 0mm, 0mm))
  SMA_Dielectric4 [Teflon (tm)] = cylinder(axis=Y, base_centre=(0mm, -47.49mm, 0mm), radius=2.05mm, height=7mm)
  13235715 = imported_body(C:\Users\Joshua Wong\Downloads\132357-11.stp)
  13235715.rotate(axis=Z, angle=90deg)
  13235715.rotate(axis=Y, angle=90deg)
  13235715.move(0mm, -40mm, 0mm)
  Cylinder5 = cylinder(axis=Y, base_centre=(0mm, -47.49mm, 0mm), radius=2.05mm, height=7mm)
  13235715.subtract(Cylinder5)
  13235711_ObjectFromFace5 = object_from(SMA_Probe4.face(at (0, -40.49, 0)))
  SMA_Probe4 [copper] = sweep_along_normal(13235711_ObjectFromFace5.face, length=7mm)
  SMA_Probe4.unite(13235715)
  13235711_ObjectFromFace1_SweepFaceAlongNormal1_5 = SMA_Probe4.copy()
  SMA_Dielectric4.subtract(13235711_ObjectFromFace1_SweepFaceAlongNormal1_5)
  13235711_ObjectFromFace5.delete()
  SMA_Dielectric4.move(-board_X/4, 40mm-board_Y/2, 1.76mm)
  SMA_Dielectric4.mirror(point=(0mm, 0mm, 0mm), normal=(0mm, 1mm, 0mm))
  SMA_Dielectric4.move(-(Resistor_CtoC/2)-offset-L_Split*cos(split_angle), 0mm, 0mm)
  SMA_Body4 [brass] = SMA_Probe4.separate_bodies()
  SMA_Probe4.move(-board_X/4, 40mm-board_Y/2, 1.76mm)
  SMA_Probe4.mirror(point=(0mm, 0mm, 0mm), normal=(0mm, 1mm, 0mm))
  SMA_Probe4.move(-(Resistor_CtoC/2)-offset-L_Split*cos(split_angle), 0mm, 0mm)
  SMA_Body4.move(-board_X/4, 40mm-board_Y/2, 1.76mm)
  SMA_Body4.mirror(point=(0mm, 0mm, 0mm), normal=(0mm, 1mm, 0mm))
  SMA_Body4.move(-(Resistor_CtoC/2)-offset-L_Split*cos(split_angle), 0mm, 0mm)
  Pad9 = rectangle(corner=(-(board_X/4)-(SMA_Pad_Separation/2)-(SMA_Pad_W/2), -board_Y/2, board_Z), x_size=SMA_Pad_W, y_size=SMA_Pad_H)
  Pad9.thicken(copper_thickness)
  Pad10 = Pad9.duplicate_mirror(point=(-board_X/4, -18mm, 1.635mm), normal=(-1mm, 0mm, 0mm))
  Pad9.mirror(point=(0mm, 0mm, 0mm), normal=(0mm, 1mm, 0mm))
  Pad9.move(-(Resistor_CtoC/2)-offset-L_Split*cos(split_angle), 0mm, 0mm)
  Pad10.mirror(point=(0mm, 0mm, 0mm), normal=(0mm, 1mm, 0mm))
  Pad10.move(-(Resistor_CtoC/2)-offset-L_Split*cos(split_angle), 0mm, 0mm)
  Vias_Pad9 = cylinder(axis=Z, base_centre=(-(board_X/4)-(SMA_Pad_Separation/2), -board_Y/2+Via_edge_spacing, 0), radius=Via_Radius, height=board_Z)
  Vias_Pad9.duplicate_along_line(step=(0mm, Via_center_spacing, 0mm), total=4, attached)
  Vias_Pad10 = Vias_Pad9.duplicate_mirror(point=(-board_X/4, -18mm, 1.635mm), normal=(1mm, 0mm, 0mm))
  Vias_Pad9.mirror(point=(0mm, 0mm, 0mm), normal=(0mm, 1mm, 0mm))
  Vias_Pad9.move(-(Resistor_CtoC/2)-offset-L_Split*cos(split_angle), 0mm, 0mm)
  Vias_Pad10.mirror(point=(0mm, 0mm, 0mm), normal=(0mm, 1mm, 0mm))
  Vias_Pad10.move(-(Resistor_CtoC/2)-offset-L_Split*cos(split_angle), 0mm, 0mm)
  SMA_Dielectric5 [Teflon (tm)] = cylinder(axis=Y, base_centre=(0mm, -47.49mm, 0mm), radius=2.05mm, height=7mm)
  13235716 = imported_body(C:\Users\Joshua Wong\Downloads\132357-11.stp)
  13235716.rotate(axis=Z, angle=90deg)
  13235716.rotate(axis=Y, angle=90deg)
  13235716.move(0mm, -40mm, 0mm)
  Cylinder6 = cylinder(axis=Y, base_centre=(0mm, -47.49mm, 0mm), radius=2.05mm, height=7mm)
  13235716.subtract(Cylinder6)
  13235711_ObjectFromFace6 = object_from(SMA_Probe5.face(at (0, -40.49, 0)))
  SMA_Probe5 [copper] = sweep_along_normal(13235711_ObjectFromFace6.face, length=7mm)
  SMA_Probe5.unite(13235716)
  13235711_ObjectFromFace1_SweepFaceAlongNormal1_6 = SMA_Probe5.copy()
  SMA_Dielectric5.subtract(13235711_ObjectFromFace1_SweepFaceAlongNormal1_6)
  13235711_ObjectFromFace6.delete()
  SMA_Dielectric5.move(-board_X/4, 40mm-board_Y/2, 1.76mm)
  SMA_Dielectric5.mirror(point=(0mm, 0mm, 0mm), normal=(0mm, 1mm, 0mm))
  SMA_Dielectric5.move(-(Resistor_CtoC/2)-offset-L_Split*cos(split_angle), 0mm, 0mm)
  SMA_Dielectric5.mirror(point=(-17.5mm, 0mm, 0mm), normal=(1mm, 0mm, 0mm))
  SMA_Body5 [brass] = SMA_Probe5.separate_bodies()
  SMA_Probe5.move(-board_X/4, 40mm-board_Y/2, 1.76mm)
  SMA_Probe5.mirror(point=(0mm, 0mm, 0mm), normal=(0mm, 1mm, 0mm))
  SMA_Probe5.move(-(Resistor_CtoC/2)-offset-L_Split*cos(split_angle), 0mm, 0mm)
  SMA_Probe5.mirror(point=(-board_X/4, 0mm, 0mm), normal=(1mm, 0mm, 0mm))
  SMA_Body5.move(-board_X/4, 40mm-board_Y/2, 1.76mm)
  SMA_Body5.mirror(point=(0mm, 0mm, 0mm), normal=(0mm, 1mm, 0mm))
  SMA_Body5.move(-(Resistor_CtoC/2)-offset-L_Split*cos(split_angle), 0mm, 0mm)
  SMA_Body5.mirror(point=(-board_X/4, 0mm, 0mm), normal=(1mm, 0mm, 0mm))
  Pad11 = rectangle(corner=(-(board_X/4)-(SMA_Pad_Separation/2)-(SMA_Pad_W/2), -board_Y/2, board_Z), x_size=SMA_Pad_W, y_size=SMA_Pad_H)
  Pad11.thicken(copper_thickness)
  Pad12 = Pad11.duplicate_mirror(point=(-board_X/4, -18mm, 1.635mm), normal=(-1mm, 0mm, 0mm))
  Pad11.mirror(point=(0mm, 0mm, 0mm), normal=(0mm, 1mm, 0mm))
  Pad11.move(-(Resistor_CtoC/2)-offset-L_Split*cos(split_angle), 0mm, 0mm)
  Pad11.mirror(point=(-board_X/4, 0mm, 0mm), normal=(1mm, 0mm, 0mm))
  Pad12.mirror(point=(0mm, 0mm, 0mm), normal=(0mm, 1mm, 0mm))
  Pad12.move(-(Resistor_CtoC/2)-offset-L_Split*cos(split_angle), 0mm, 0mm)
  Pad12.mirror(point=(-board_X/4, 0mm, 0mm), normal=(1mm, 0mm, 0mm))
  Vias_Pad11 = cylinder(axis=Z, base_centre=(-(board_X/4)-(SMA_Pad_Separation/2), -board_Y/2+Via_edge_spacing, 0), radius=Via_Radius, height=board_Z)
  Vias_Pad11.duplicate_along_line(step=(0mm, Via_center_spacing, 0mm), total=4, attached)
  Vias_Pad12 = Vias_Pad11.duplicate_mirror(point=(-board_X/4, -18mm, 1.635mm), normal=(1mm, 0mm, 0mm))
  Vias_Pad11.mirror(point=(0mm, 0mm, 0mm), normal=(0mm, 1mm, 0mm))
  Vias_Pad11.move(-(Resistor_CtoC/2)-offset-L_Split*cos(split_angle), 0mm, 0mm)
  Vias_Pad11.mirror(point=(-board_X/4, 0mm, 0mm), normal=(1mm, 0mm, 0mm))
  Vias_Pad12.mirror(point=(0mm, 0mm, 0mm), normal=(0mm, 1mm, 0mm))
  Vias_Pad12.move(-(Resistor_CtoC/2)-offset-L_Split*cos(split_angle), 0mm, 0mm)
  Vias_Pad12.mirror(point=(-board_X/4, 0mm, 0mm), normal=(1mm, 0mm, 0mm))
  [SMA_Dielectric3, SMA_Probe3, SMA_Body3, Pad7, Pad8, Vias_Pad7, Vias_Pad8, SMA_Dielectric4, SMA_Probe4, SMA_Body4, Pad9, Pad10, Vias_Pad9, Vias_Pad10, SMA_Dielectric5, SMA_Probe5, SMA_Body5, Pad11, Pad12, Vias_Pad11, Vias_Pad12].mirror(point=(0mm, 0mm, 0mm), normal=(1mm, 0mm, 0mm))
  Ground.unite(Pad11, Pad12, Vias_Pad11, Vias_Pad12, Pad9, Pad10, Vias_Pad9, Vias_Pad10, Pad7, Pad8, Vias_Pad7, Vias_Pad8, Vias_Pad6, Vias_Pad5, Pad6, Pad5, Pad3, Pad4, Vias_Pad3, Vias_Pad4, Pad1, Pad2, Vias_Pad1, Vias_Pad2)
  group SMA_Port1 = SMA_Dielectric, SMA_Probe, SMA_Body
  group SMA_Port2 = SMA_Dielectric1, SMA_Probe1, SMA_Body1
  group SMA_Port3 = SMA_Dielectric2, SMA_Probe2, SMA_Body2
  group SMA_Port4 = SMA_Dielectric3, SMA_Probe3, SMA_Body3
  group SMA_Port5 = SMA_Dielectric4, SMA_Probe4, SMA_Body4
  group SMA_Port6 = SMA_Dielectric5, SMA_Probe5, SMA_Body5
boundaries and excitations:
  Ground: Perfect E Objects=Ground
  LumpRLC1: Lumped RLC Objects=Resistor_100ohms CurrentLine{(-17.675, 6.5828535, 1.6) -> (-17.325, 6.5828535, 1.6)} RLC_Type=Serial Resistance=100ohm
  Open1: Radiation Objects=RadiatingSurface
  Copper_trace: Perfect E Objects=Copper_trace_2245
  Copper_trace1: Perfect E Objects=Copper_trace_2067
  LumpRLC2: Lumped RLC Objects=Resistor_100ohms_2067 CurrentLine{(17.325, 7.7924311, 1.6) -> (17.675, 7.7924311, 1.6)} RLC_Type=Serial Resistance=100ohm
  reference conductors: Ground
setups:
  2245: HfssDriven Frequency=2.245GHz MaxDeltaE=0.1 MaximumPasses=20 MinimumPasses=1 MinimumConvergedPasses=1 PercentRefinement=30 disabled BasisOrder=1 DrivenSolverType="Direct Solver"
    sweep Sweep: 1GHz to 3.5GHz step 10MHz; Type=Interpolating InterpTolerance=0.5 InterpMaxSolns=250 PassivityErrorTolerance=0.0001
  2067: HfssDriven Frequency=2.067GHz MaxDeltaE=0.1 MaximumPasses=20 MinimumPasses=1 MinimumConvergedPasses=1 PercentRefinement=30 disabled BasisOrder=1 DrivenSolverType="Direct Solver"
    sweep Sweep: 1GHz to 3.5GHz step 10MHz; Type=Interpolating InterpTolerance=0.5 InterpMaxSolns=250 PassivityErrorTolerance=0.0001
  both_frequencies: HfssDriven Frequency=5GHz MaxDeltaE=0.1 MaximumPasses=20 MinimumPasses=1 MinimumConvergedPasses=1 PercentRefinement=30 BasisOrder=1 DrivenSolverType="Direct Solver"
    sweep Sweep: 1GHz to 3.5GHz step 10MHz; Type=Interpolating InterpTolerance=0.5 InterpMaxSolns=250 PassivityErrorTolerance=0.0001
optimetrics:
  quarterwave_2245_sweep: Parametric Sim._Setups=[both_frequencies]
    sweep quarterwave_2245: LIN 26.3mm 26.5mm 0.1mm
  quarterwave_2067_sweep: Parametric Sim._Setups=[both_frequencies]
    sweep quarterwave_2067: LIN 28mm 29mm 0.2mm
  W_50_sweep: Parametric Sim._Setups=[both_frequencies]
    sweep W_50: LIN 2.8mm 3mm 0.05mm
  er_FR4_sweep: Parametric Sim._Setups=[both_frequencies]
    sweep $er_FR4: 4.1 4.4 4.8
radiation setups:
  3D: Infinite Sphere Theta=0deg..180deg step 2deg Phi=-180deg..180deg step 2deg
  Elevation: Infinite Sphere Theta=-180deg..180deg step 1deg Phi=0deg..90deg step 90deg
  Azimuth: Infinite Sphere Theta=90deg..90deg step 0deg Phi=-180deg..180deg step 1deg
reports:
  Terminal S Parameter Plot1: dB(St(Port1_T,Port1_T)), dB(St(Port2_T,Port1_T)), dB(St(Port3_T,Port1_T)), dB(St(Port1_T,Port2_T)), dB(St(Port2_T,Port2_T)), dB(St(Port3_T,Port2_T)), dB(St(Port1_T,Port3_T)), dB(St(Port2_T,Port3_T)), dB(St(Port3_T,Port3_T)) vs Freq on both_frequencies : Sweep; markers MX1 at x=2.245e+09
  Terminal S Parameter Plot2: dB(St(Port4_T,Port4_T)), dB(St(Port5_T,Port4_T)), dB(St(Port6_T,Port4_T)), dB(St(Port4_T,Port5_T)), dB(St(Port5_T,Port5_T)), dB(St(Port6_T,Port5_T)), dB(St(Port4_T,Port6_T)), dB(St(Port5_T,Port6_T)), dB(St(Port6_T,Port6_T)) vs Freq on both_frequencies : Sweep; markers MX1 at x=2.067e+09
  Phase (2245): ang_deg(St(Port2_T,Port1_T)), ang_deg(St(Port3_T,Port1_T)), ang_deg(St(Port2_T,Port1_T)/St(Port3_T,Port1_T)) vs Freq on both_frequencies : Sweep; markers MX1 at x=2.245e+09
  Phase (2067): ang_deg(St(Port5_T,Port4_T)), ang_deg(St(Port6_T,Port4_T)), ang_deg(St(Port5_T,Port4_T)/St(Port6_T,Port4_T)) vs Freq on both_frequencies : Sweep; markers MX1 at x=2.0672515e+09
  Terminal S Parameter Plot3: dB(St(Port1_T,Port1_T)) vs Freq on both_frequencies : Sweep [$er_FR4=all]; markers MX1 at x=2.2454068e+09
  Terminal S Parameter Plot4: dB(St(Port4_T,Port4_T)) vs Freq on both_frequencies : Sweep [$er_FR4=all]; markers MX1 at x=2.0674157e+09

design Wilkinson_V5 (HFSS, HFSS Terminal Network, model units mm)
options: Allow_Material_Override
variables:
  board_X = 70mm
  board_Y = 36mm
  board_Z = 1.6mm
  W_50 = 2.92mm  # 50 Ohm trace width
  L_Port1_Trace = 8mm  # Port 1 trace length
  W_70p7 = 1.45mm  # 70.7 Ohm trace width
  Resistor_CtoC = 0.35mm  # 0603 footprint copper to copper distance
  quarterwave_2245 = 26mm
  Radius = (quarterwave_2245-(Resistor_CtoC/2))/pi
  turn_radius = 5mm
  L_Split = 6mm
  offset = 3.5mm
  split_angle = 60deg  # Angle from X-axis to diagonal trace
  fillet_radius = 3mm
  W_50_2067 = 2.92mm
  L_Port1_Trace_2067 = 8mm
  W_70p7_2067 = 1.45mm
  quarterwave_2067 = 27.7mm
  Radius_2067 = (quarterwave_2067-(Resistor_CtoC/2))/pi
  L_split_2067 = 6mm
  offset_2067 = 3.5mm
  split_angle_2067 = 60deg
  copper_thickness = 0.035mm
  er_FR4 = 4.5
  SMA_Pad_W = 2.415mm
  SMA_Pad_H = 5.84mm
  SMA_Pad_Separation = 8.765mm
  Resistor_Height = 0.5mm
  Via_Radius = 0.15mm
  Via_edge_spacing = 1.2mm
  Via_center_spacing = 1.2mm
  Via_quantity = 3
  Resistor_pad_W = 0.45mm
  Resistor_pad_H = 0.6mm
  Solderblob_H = 5.4mm
  Center_probe_rad = 0.38mm
  Center_probe_length = 4.75mm
  Soldermask_clearance = 0.075mm
  Soldermask_dam_W = 0.2mm
  Solermask_thickness = 0.02mm
  Port_Rad = 2.1081331mm
geometry:
  Ground [copper] = rectangle(corner=(-board_X/2, -board_Y/2, 0mm), x_size=board_X, y_size=board_Y)
  Substrate [FR4_epoxy_Wilkinson] = box(corner=(-board_X/2, -board_Y/2, 0mm), size=(board_X, board_Y, board_Z))
  Port1_50ohms = rectangle(corner=(-(board_X/4)-(W_50/2), -board_Y/2, 1.6mm), x_size=W_50, y_size=L_Port1_Trace)
  Stub_1 = rectangle(corner=(-(board_X/4)-(Resistor_CtoC/2), -(board_Y/2)+L_Port1_Trace-(W_70p7/2), board_Z), x_size=Resistor_CtoC/2, y_size=W_70p7)
  Stub_2 = rectangle(corner=(-(board_X/4), -(board_Y/2)+L_Port1_Trace-(W_70p7/2), board_Z), x_size=Resistor_CtoC/2, y_size=W_70p7)
  Arc_1_Line = polyline((-(board_X/4)-(Resistor_CtoC/2), -(board_Y/2)+L_Port1_Trace, board_Z) (-25.895353mm, -1.7796472mm, 1.6mm) (-17.675mm, 6.4407056mm, 1.6mm), AngularArc from point 0 over 3 centre=(-(board_X/4)-(Resistor_CtoC/2), -(board_Y/2)+L_Port1_Trace+Radius, board_Z) angle=-180deg plane=XY)
  Arc_1_Line1 = polyline((-(board_X/4)+(Resistor_CtoC/2), -(board_Y/2)+L_Port1_Trace, board_Z) (-9.1046472mm, -1.7796472mm, 1.6mm) (-17.325mm, 6.4407056mm, 1.6mm), AngularArc from point 0 over 3 centre=(-(board_X/4)+(Resistor_CtoC/2), -(board_Y/2)+L_Port1_Trace+Radius, board_Z) angle=180deg plane=XY)
  Arc_1 = polyline((-(board_X/4)-(Resistor_CtoC/2), -(board_Y/2)+L_Port1_Trace-(W_70p7/2), board_Z) (-(board_X/4)-(Resistor_CtoC/2), -(board_Y/2)+L_Port1_Trace+(W_70p7/2), board_Z))
  Arc_1.sweep_along_path(Arc_1_Line)
  Arc_2 = polyline((-(board_X/4)+(Resistor_CtoC/2), -(board_Y/2)+L_Port1_Trace-(W_70p7/2), board_Z) (-(board_X/4)+(Resistor_CtoC/2), -(board_Y/2)+L_Port1_Trace+(W_70p7/2), board_Z))
  Arc_2.sweep_along_path(Arc_1_Line1)
  Resistor_100ohms = rectangle(corner=(-(board_X/4)-(Resistor_CtoC/2), -(board_Y/2)+L_Port1_Trace+2*Radius-(W_70p7 /2)+(W_70p7/4), board_Z), x_size=Resistor_CtoC, y_size=Resistor_Height)
  RadiatingSurface [vacuum] = region(absolute_offset=44.54343mm on all sides)
  Polyline2 = polyline((-(board_X/4)-(Resistor_CtoC/2)-offset, -(board_Y/2)+L_Port1_Trace+2*Radius-(W_70p7 /2), board_Z) (-(board_X/4)-(Resistor_CtoC/2)-offset-L_Split*cos(split_angle), -(board_Y/2)+L_Port1_Trace+2*Radius-(W_70p7 /2)+L_Split*sin(split_angle), board_Z))
  Copper_trace_2245 [copper] = polyline((-(board_X/4)-(Resistor_CtoC/2)-offset -(W_50/2)*sin(split_angle), -(board_Y/2)+L_Port1_Trace+2*Radius-(W_70p7 /2)-(W_50/2)*cos(split_angle), board_Z) (-(board_X/4)-(Resistor_CtoC/2)-offset +(W_50/2)*sin(split_angle), -(board_Y/2)+L_Port1_Trace+2*Radius-(W_70p7 /2)+(W_50/2)*cos(split_angle), board_Z))
  Polyline4 = polyline((-(board_X/4)-(Resistor_CtoC/2)-offset-L_Split*cos(split_angle), -(board_Y/2)+L_Port1_Trace+2*Radius-(W_70p7 /2)+L_Split*sin(split_angle), board_Z) (-(board_X/4)-(Resistor_CtoC/2)-offset-L_Split*cos(split_angle), (board_Y/2), board_Z))
  Polyline4.unite(Polyline2)
  Copper_trace_2245.sweep_along_path(Polyline4)
  Copper_trace_2245.fillet(Vertices=Copper_trace_2245.vertex(at (-22.715, 11.3031, 1.6), at (-25.635, 10.5207, 1.6)) Radius=fillet_radius Setback=0mm)
  Polyline5 = polyline((-(board_X/4)-(Resistor_CtoC/2)-offset -(W_50/2)*sin(split_angle), -(board_Y/2)+L_Port1_Trace+2*Radius-(W_70p7 /2)-(W_50/2)*cos(split_angle), board_Z) (-(board_X/4)-(Resistor_CtoC/2)-offset +(W_50/2)*sin(split_angle), -(board_Y/2)+L_Port1_Trace+2*Radius-(W_70p7 /2)+(W_50/2)*cos(split_angle), board_Z))
  Polyline7 = polyline((-(board_X/4)-(Resistor_CtoC/2)-offset-L_Split*cos(split_angle), -(board_Y/2)+L_Port1_Trace+2*Radius-(W_70p7 /2)+L_Split*sin(split_angle), board_Z) (-(board_X/4)-(Resistor_CtoC/2)-offset-L_Split*cos(split_angle), (board_Y/2), board_Z))
  Polyline6 = polyline((-(board_X/4)-(Resistor_CtoC/2)-offset, -(board_Y/2)+L_Port1_Trace+2*Radius-(W_70p7 /2), board_Z) (-(board_X/4)-(Resistor_CtoC/2)-offset-L_Split*cos(split_angle), -(board_Y/2)+L_Port1_Trace+2*Radius-(W_70p7 /2)+L_Split*sin(split_angle), board_Z))
  Polyline7.unite(Polyline6)
  Polyline5.sweep_along_path(Polyline7)
  Polyline5.fillet(Vertices=Copper_trace_2245.vertex(at (-22.715, 11.3031, 1.6), at (-25.635, 10.5207, 1.6)) Radius=fillet_radius Setback=0mm)
  Polyline5.mirror(point=(-17.5mm, 5.9157337mm, 1.6mm), normal=(-1mm, 0mm, 0mm))
  Copper_trace_2245.unite(Arc_1, Polyline5, Stub_1, Arc_2, Stub_2, Port1_50ohms)
  Copper_trace_2067 [copper] = polyline((-(board_X/4)-(Resistor_CtoC/2)-offset_2067 -(W_50_2067/2)*sin(split_angle_2067), -(board_Y/2)+L_Port1_Trace_2067+2*Radius_2067-(W_70p7_2067 /2)-(W_50_2067/2)*cos(split_angle_2067), board_Z) (-(board_X/4)-(Resistor_CtoC/2)-offset_2067 +(W_50_2067/2)*sin(split_angle_2067), -(board_Y/2)+L_Port1_Trace_2067+2*Radius_2067-(W_70p7_2067 /2)+(W_50_2067/2)*cos(split_angle_2067), board_Z))
  Polyline9 = polyline((-(board_X/4)-(Resistor_CtoC/2)-offset_2067-L_Split_2067*cos(split_angle_2067), -(board_Y/2)+L_Port1_Trace_2067+2*Radius_2067-(W_70p7_2067 /2)+L_Split_2067*sin(split_angle_2067), board_Z) (-(board_X/4)-(Resistor_CtoC/2)-offset_2067-L_Split_2067*cos(split_angle_2067), (board_Y/2), board_Z))
  Polyline8 = polyline((-(board_X/4)-(Resistor_CtoC/2)-offset_2067, -(board_Y/2)+L_Port1_Trace_2067+2*Radius_2067-(W_70p7_2067 /2), board_Z) (-(board_X/4)-(Resistor_CtoC/2)-offset_2067-L_Split_2067*cos(split_angle_2067), -(board_Y/2)+L_Port1_Trace_2067+2*Radius_2067-(W_70p7_2067 /2)+L_Split_2067*sin(split_angle_2067), board_Z))
  Polyline9.unite(Polyline8)
  Copper_trace_2067.sweep_along_path(Polyline9)
  Copper_trace_2067.fillet(Vertices=Copper_trace_2067.vertex(at (-22.715, 12.3853, 1.6), at (-25.635, 11.6029, 1.6)) Radius=fillet_radius Setback=0mm)
  Arc_3 = polyline((-(board_X/4)-(Resistor_CtoC/2), -(board_Y/2)+L_Port1_Trace_2067-(W_70p7_2067/2), board_Z) (-(board_X/4)-(Resistor_CtoC/2), -(board_Y/2)+L_Port1_Trace_2067+(W_70p7_2067/2), board_Z))
  Arc_1_Line2 = polyline((-(board_X/4)-(Resistor_CtoC/2), -(board_Y/2)+L_Port1_Trace_2067, board_Z) (-26.43648mm, -1.2385204mm, 1.6mm) (-17.675mm, 7.5229592mm, 1.6mm), AngularArc from point 0 over 3 centre=(-(board_X/4)-(Resistor_CtoC/2), -(board_Y/2)+L_Port1_Trace_2067+Radius_2067, board_Z) angle=-180deg plane=XY)
  Arc_3.sweep_along_path(Arc_1_Line2)
  Polyline10 = polyline((-(board_X/4)-(Resistor_CtoC/2)-offset_2067 -(W_50_2067/2)*sin(split_angle_2067), -(board_Y/2)+L_Port1_Trace_2067+2*Radius_2067-(W_70p7_2067/2)-(W_50_2067/2)*cos(split_angle_2067), board_Z) (-(board_X/4)-(Resistor_CtoC/2)-offset_2067 +(W_50_2067/2)*sin(split_angle_2067), -(board_Y/2)+L_Port1_Trace_2067+2*Radius_2067-(W_70p7_2067/2)+(W_50_2067/2)*cos(split_angle_2067), board_Z))
  Polyline12 = polyline((-(board_X/4)-(Resistor_CtoC/2)-offset_2067-L_Split_2067*cos(split_angle_2067), -(board_Y/2)+L_Port1_Trace_2067+2*Radius_2067-(W_70p7_2067/2)+L_Split_2067*sin(split_angle_2067), board_Z) (-(board_X/4)-(Resistor_CtoC/2)-offset_2067-L_Split_2067*cos(split_angle_2067), (board_Y/2), board_Z))
  Polyline11 = polyline((-(board_X/4)-(Resistor_CtoC/2)-offset_2067, -(board_Y/2)+L_Port1_Trace_2067+2*Radius_2067-(W_70p7_2067 /2), board_Z) (-(board_X/4)-(Resistor_CtoC/2)-offset_2067-L_Split_2067*cos(split_angle_2067), -(board_Y/2)+L_Port1_Trace_2067+2*Radius_2067-(W_70p7_2067 /2)+L_Split_2067*sin(split_angle_2067), board_Z))
  Polyline12.unite(Polyline11)
  Polyline10.sweep_along_path(Polyline12)
  Polyline10.fillet(Vertices=Copper_trace_2067.vertex(at (-22.715, 12.3853, 1.6), at (-25.635, 11.6029, 1.6)) Radius=fillet_radius Setback=0mm)
  Polyline10.mirror(point=(-17.5mm, 5.9157337mm, 1.6mm), normal=(-1mm, 0mm, 0mm))
  Stub_3 = rectangle(corner=(-(board_X/4)-(Resistor_CtoC/2), -(board_Y/2)+L_Port1_Trace_2067-(W_70p7_2067/2), board_Z), x_size=Resistor_CtoC/2, y_size=W_70p7_2067)
  Arc_4 = polyline((-(board_X/4)+(Resistor_CtoC/2), -(board_Y/2)+L_Port1_Trace_2067-(W_70p7_2067/2), board_Z) (-(board_X/4)+(Resistor_CtoC/2), -(board_Y/2)+L_Port1_Trace_2067+(W_70p7_2067/2), board_Z))
  Arc_1_Line3 = polyline((-(board_X/4)+(Resistor_CtoC/2), -(board_Y/2)+L_Port1_Trace_2067, board_Z) (-8.5635204mm, -1.2385204mm, 1.6mm) (-17.325mm, 7.5229592mm, 1.6mm), AngularArc from point 0 over 3 centre=(-(board_X/4)+(Resistor_CtoC/2), -(board_Y/2)+L_Port1_Trace_2067+Radius_2067, board_Z) angle=180deg plane=XY)
  Arc_4.sweep_along_path(Arc_1_Line3)
  Stub_4 = rectangle(corner=(-(board_X/4), -(board_Y/2)+L_Port1_Trace_2067-(W_70p7_2067/2), board_Z), x_size=Resistor_CtoC/2, y_size=W_70p7_2067)
  Port1_50ohms1 = rectangle(corner=(-(board_X/4)-(W_50_2067/2), -board_Y/2, board_Z), x_size=W_50_2067, y_size=L_Port1_Trace_2067)
  Copper_trace_2067.unite(Arc_3, Polyline10, Stub_3, Arc_4, Stub_4, Port1_50ohms1)
  Copper_trace_2067.mirror(point=(0mm, 0mm, 0mm), normal=(1mm, 0mm, 0mm))
  Resistor_100ohms_2067 = rectangle(corner=((board_X/4)-(Resistor_CtoC/2), -(board_Y/2)+L_Port1_Trace_2067+2*Radius_2067-(W_70p7_2067/2)+(W_70p7_2067/4), board_Z), x_size=Resistor_CtoC, y_size=Resistor_Height)
  [Copper_trace_2245, Copper_trace_2067].thicken(copper_thickness)
  Ground.thicken(-copper_thickness)
  Pad1 = rectangle(corner=(-(board_X/4)-(SMA_Pad_Separation/2)-(SMA_Pad_W/2), -board_Y/2, board_Z), x_size=SMA_Pad_W, y_size=SMA_Pad_H)
  Pad1.thicken(copper_thickness)
  Pad2 = Pad1.duplicate_mirror(point=(-board_X/4, -18mm, 1.635mm), normal=(-1mm, 0mm, 0mm))
  Vias_Pad1 = cylinder(axis=Z, base_centre=(-(board_X/4)-(SMA_Pad_Separation/2), -board_Y/2+Via_edge_spacing, 0), radius=Via_Radius, height=board_Z)
  Vias_Pad1.duplicate_along_line(step=(0mm, Via_center_spacing, 0mm), total=Via_quantity, attached)
  Vias_Pad2 = Vias_Pad1.duplicate_mirror(point=(-board_X/4, -18mm, 1.635mm), normal=(1mm, 0mm, 0mm))
  Pad3 = rectangle(corner=(-(board_X/4)-(SMA_Pad_Separation/2)-(SMA_Pad_W/2), -board_Y/2, board_Z), x_size=SMA_Pad_W, y_size=SMA_Pad_H)
  Pad3.thicken(copper_thickness)
  Pad4 = Pad3.duplicate_mirror(point=(-board_X/4, -18mm, 1.635mm), normal=(-1mm, 0mm, 0mm))
  Vias_Pad3 = cylinder(axis=Z, base_centre=(-(board_X/4)-(SMA_Pad_Separation/2), -board_Y/2+Via_edge_spacing, 0), radius=Via_Radius, height=board_Z)
  Vias_Pad3.duplicate_along_line(step=(0mm, Via_center_spacing, 0mm), total=Via_quantity, attached)
  Vias_Pad4 = Vias_Pad3.duplicate_mirror(point=(-board_X/4, -18mm, 1.635mm), normal=(1mm, 0mm, 0mm))
  [Pad3, Pad4, Vias_Pad3, Vias_Pad4].mirror(point=(0mm, 0mm, 0mm), normal=(0mm, 1mm, 0mm))
  [Pad3, Pad4, Vias_Pad3, Vias_Pad4].move(-(Resistor_CtoC/2)-offset-L_Split*cos(split_angle), 0mm, 0mm)
  Pad5 = rectangle(corner=(-(board_X/4)-(SMA_Pad_Separation/2)-(SMA_Pad_W/2), -board_Y/2, board_Z), x_size=SMA_Pad_W, y_size=SMA_Pad_H)
  Pad5.thicken(copper_thickness)
  Pad6 = Pad5.duplicate_mirror(point=(-board_X/4, -18mm, 1.635mm), normal=(-1mm, 0mm, 0mm))
  Pad5.mirror(point=(0mm, 0mm, 0mm), normal=(0mm, 1mm, 0mm))
  Pad5.move(-(Resistor_CtoC/2)-offset-L_Split*cos(split_angle), 0mm, 0mm)
  Pad6.mirror(point=(0mm, 0mm, 0mm), normal=(0mm, 1mm, 0mm))
  Pad6.move(-(Resistor_CtoC/2)-offset-L_Split*cos(split_angle), 0mm, 0mm)
  Vias_Pad5 = cylinder(axis=Z, base_centre=(-(board_X/4)-(SMA_Pad_Separation/2), -board_Y/2+Via_edge_spacing, 0), radius=Via_Radius, height=board_Z)
  Vias_Pad5.duplicate_along_line(step=(0mm, Via_center_spacing, 0mm), total=Via_quantity, attached)
  Vias_Pad6 = Vias_Pad5.duplicate_mirror(point=(-board_X/4, -18mm, 1.635mm), normal=(1mm, 0mm, 0mm))
  Vias_Pad5.mirror(point=(0mm, 0mm, 0mm), normal=(0mm, 1mm, 0mm))
  Vias_Pad5.move(-(Resistor_CtoC/2)-offset-L_Split*cos(split_angle), 0mm, 0mm)
  Vias_Pad6.mirror(point=(0mm, 0mm, 0mm), normal=(0mm, 1mm, 0mm))
  Vias_Pad6.move(-(Resistor_CtoC/2)-offset-L_Split*cos(split_angle), 0mm, 0mm)
  [Pad5, Pad6, Vias_Pad5, Vias_Pad6].mirror(point=(-board_X/4, 0mm, 0mm), normal=(1mm, 0mm, 0mm))
  Pad7 = rectangle(corner=(-(board_X/4)-(SMA_Pad_Separation/2)-(SMA_Pad_W/2), -board_Y/2, board_Z), x_size=SMA_Pad_W, y_size=SMA_Pad_H)
  Pad7.thicken(copper_thickness)
  Pad8 = Pad7.duplicate_mirror(point=(-board_X/4, -18mm, 1.635mm), normal=(-1mm, 0mm, 0mm))
  Vias_Pad7 = cylinder(axis=Z, base_centre=(-(board_X/4)-(SMA_Pad_Separation/2), -board_Y/2+Via_edge_spacing, 0), radius=Via_Radius, height=board_Z)
  Vias_Pad7.duplicate_along_line(step=(0mm, Via_center_spacing, 0mm), total=Via_quantity, attached)
  Vias_Pad8 = Vias_Pad7.duplicate_mirror(point=(-board_X/4, -18mm, 1.635mm), normal=(1mm, 0mm, 0mm))
  Pad9 = rectangle(corner=(-(board_X/4)-(SMA_Pad_Separation/2)-(SMA_Pad_W/2), -board_Y/2, board_Z), x_size=SMA_Pad_W, y_size=SMA_Pad_H)
  Pad9.thicken(copper_thickness)
  Pad10 = Pad9.duplicate_mirror(point=(-board_X/4, -18mm, 1.635mm), normal=(-1mm, 0mm, 0mm))
  Pad9.mirror(point=(0mm, 0mm, 0mm), normal=(0mm, 1mm, 0mm))
  Pad9.move(-(Resistor_CtoC/2)-offset-L_Split*cos(split_angle), 0mm, 0mm)
  Pad10.mirror(point=(0mm, 0mm, 0mm), normal=(0mm, 1mm, 0mm))
  Pad10.move(-(Resistor_CtoC/2)-offset-L_Split*cos(split_angle), 0mm, 0mm)
  Vias_Pad9 = cylinder(axis=Z, base_centre=(-(board_X/4)-(SMA_Pad_Separation/2), -board_Y/2+Via_edge_spacing, 0), radius=Via_Radius, height=board_Z)
  Vias_Pad9.duplicate_along_line(step=(0mm, Via_center_spacing, 0mm), total=Via_quantity, attached)
  Vias_Pad10 = Vias_Pad9.duplicate_mirror(point=(-board_X/4, -18mm, 1.635mm), normal=(1mm, 0mm, 0mm))
  Vias_Pad9.mirror(point=(0mm, 0mm, 0mm), normal=(0mm, 1mm, 0mm))
  Vias_Pad9.move(-(Resistor_CtoC/2)-offset-L_Split*cos(split_angle), 0mm, 0mm)
  Vias_Pad10.mirror(point=(0mm, 0mm, 0mm), normal=(0mm, 1mm, 0mm))
  Vias_Pad10.move(-(Resistor_CtoC/2)-offset-L_Split*cos(split_angle), 0mm, 0mm)
  Pad11 = rectangle(corner=(-(board_X/4)-(SMA_Pad_Separation/2)-(SMA_Pad_W/2), -board_Y/2, board_Z), x_size=SMA_Pad_W, y_size=SMA_Pad_H)
  Pad11.thicken(copper_thickness)
  Pad12 = Pad11.duplicate_mirror(point=(-board_X/4, -18mm, 1.635mm), normal=(-1mm, 0mm, 0mm))
  Pad11.mirror(point=(0mm, 0mm, 0mm), normal=(0mm, 1mm, 0mm))
  Pad11.move(-(Resistor_CtoC/2)-offset-L_Split*cos(split_angle), 0mm, 0mm)
  Pad11.mirror(point=(-board_X/4, 0mm, 0mm), normal=(1mm, 0mm, 0mm))
  Pad12.mirror(point=(0mm, 0mm, 0mm), normal=(0mm, 1mm, 0mm))
  Pad12.move(-(Resistor_CtoC/2)-offset-L_Split*cos(split_angle), 0mm, 0mm)
  Pad12.mirror(point=(-board_X/4, 0mm, 0mm), normal=(1mm, 0mm, 0mm))
  Vias_Pad11 = cylinder(axis=Z, base_centre=(-(board_X/4)-(SMA_Pad_Separation/2), -board_Y/2+Via_edge_spacing, 0), radius=Via_Radius, height=board_Z)
  Vias_Pad11.duplicate_along_line(step=(0mm, Via_center_spacing, 0mm), total=Via_quantity, attached)
  Vias_Pad12 = Vias_Pad11.duplicate_mirror(point=(-board_X/4, -18mm, 1.635mm), normal=(1mm, 0mm, 0mm))
  Vias_Pad11.mirror(point=(0mm, 0mm, 0mm), normal=(0mm, 1mm, 0mm))
  Vias_Pad11.move(-(Resistor_CtoC/2)-offset-L_Split*cos(split_angle), 0mm, 0mm)
  Vias_Pad11.mirror(point=(-board_X/4, 0mm, 0mm), normal=(1mm, 0mm, 0mm))
  Vias_Pad12.mirror(point=(0mm, 0mm, 0mm), normal=(0mm, 1mm, 0mm))
  Vias_Pad12.move(-(Resistor_CtoC/2)-offset-L_Split*cos(split_angle), 0mm, 0mm)
  Vias_Pad12.mirror(point=(-board_X/4, 0mm, 0mm), normal=(1mm, 0mm, 0mm))
  [Pad7, Pad8, Vias_Pad7, Vias_Pad8, Pad9, Pad10, Vias_Pad9, Vias_Pad10, Pad11, Pad12, Vias_Pad11, Vias_Pad12].mirror(point=(0mm, 0mm, 0mm), normal=(1mm, 0mm, 0mm))
  Ground.unite(Pad11, Pad12, Vias_Pad11, Vias_Pad12, Pad9, Pad10, Vias_Pad9, Vias_Pad10, Pad7, Pad8, Vias_Pad7, Vias_Pad8, Vias_Pad6, Vias_Pad5, Pad6, Pad5, Pad3, Pad4, Vias_Pad3, Vias_Pad4, Pad1, Pad2, Vias_Pad1, Vias_Pad2)
  732511153 = imported_body(C:\Users\Joshua Wong\Downloads\732511153.x_t)
  732511153.rotate(axis=X, angle=90deg)
  732511153.move(-board_X/4, -board_Y/2-9.525mm, board_Z+copper_thickness+0.3805mm)
  SMA_Dielectric [Teflon (tm)] = object_from(?.face(at (-17.5, -18.762, 2.0155)))
  SMA_Dielectric.sweep_along_vector((0mm, -6.778mm, 0mm))
  732511153_ObjectFromFace1_1 = SMA_Dielectric.copy()
  732511153.subtract(732511153_ObjectFromFace1_1)
  SMA_Body = 732511153.separate_bodies()
  Cylinder1 = cylinder(axis=Y, base_centre=(-board_X/4, -22.14mm, 2.0155mm), radius=0.6477mm, height=-3.4mm)
  732511153.subtract(Cylinder1)
  SMA_Probe [copper] = object_from(SMA_Probe.face(at (-17.5, -22.14, 2.0155)))
  SMA_Probe.sweep_along_vector((0mm, -3.4mm, 0mm))
  SMA_Probe.unite(732511153)
  Resistor_pad_outline_2245 = rectangle(corner=(-(board_X/4)-(Resistor_CtoC/2)-Resistor_pad_W, -(board_Y/2)+L_Port1_Trace+2*Radius-(W_70p7 /2)+(W_70p7/4)-(Resistor_pad_H-Resistor_Height)/2, board_Z+copper_thickness), x_size=Resistor_pad_W, y_size=Resistor_pad_H)
  Rectangle1_1 = Resistor_pad_outline_2245.duplicate_mirror(point=(-board_X/4, 6.8328535mm, 1.6mm), normal=(1mm, 0mm, 0mm))
  Resistor_pad_outline_2245.unite(Rectangle1_1)
  Resistor_pad_outline_2067 = rectangle(corner=((board_X/4)-(Resistor_CtoC/2) -Resistor_pad_W, -(board_Y/2)+L_Port1_Trace_2067+2*Radius_2067-(W_70p7_2067/2)+(W_70p7_2067/4)-(Resistor_pad_H-Resistor_Height)/2, board_Z+copper_thickness), x_size=Resistor_pad_W, y_size=Resistor_pad_H)
  Rectangle1_2 = Resistor_pad_outline_2067.duplicate_mirror(point=(board_X/4, 8.0424311mm, 1.6mm), normal=(1mm, 0mm, 0mm))
  Resistor_pad_outline_2067.unite(Rectangle1_2)
  Solder_joint_SMA = rectangle(corner=((-board_X/4)-W_50/2, -board_Y/2, board_Z+copper_thickness), x_size=W_50, y_size=Solderblob_H)
  Rectangle2 = rectangle(corner=((-board_X/4)-Center_probe_rad, -board_Y/2, board_Z+copper_thickness+Center_probe_rad), x_size=Center_probe_rad*2, y_size=Center_probe_length)
  Solder_joint_SMA.connect(Rectangle2)
  Input_Soldermask [SolderMask] = rectangle(corner=((-board_X/4)-W_50/2, -board_Y/2+Solderblob_H +Soldermask_clearance, board_Z+copper_thickness), x_size=W_50, y_size=Soldermask_dam_W)
  Input_Soldermask.thicken(Solermask_thickness)
  Resistor_soldermask_2245 [SolderMask] = rectangle(corner=(-(board_X/4)-(Resistor_CtoC/2)-Resistor_pad_W-Soldermask_clearance-Soldermask_dam_W, -(board_Y/2)+L_Port1_Trace+2*Radius-(W_70p7 /2)+(W_70p7/4)-(Resistor_pad_H-Resistor_Height)/2-Soldermask_clearance-Soldermask_dam_W, board_Z+copper_thickness), x_size=Soldermask_clearance+Soldermask_dam_W+Resistor_pad_W, y_size=2*(Soldermask_clearance+Soldermask_dam_W)+Resistor_pad_H)
  Rectangle5 = rectangle(corner=(-(board_X/4)-(Resistor_CtoC/2)-Resistor_pad_W-Soldermask_clearance, -(board_Y/2)+L_Port1_Trace+2*Radius-(W_70p7 /2)+(W_70p7/4)-(Resistor_pad_H-Resistor_Height)/2-Soldermask_clearance, board_Z+copper_thickness), x_size=Soldermask_clearance+Resistor_pad_W, y_size=2*(Soldermask_clearance)+Resistor_pad_H)
  Resistor_soldermask_2245.subtract(Rectangle5)
  Resistor_soldermask_2245.thicken(Solermask_thickness)
  Rectangle4_1 = Resistor_soldermask_2245.duplicate_mirror(point=(-board_X/4, 6.8328535mm, 1.6mm), normal=(1mm, 0mm, 0mm))
  Resistor_soldermask_2245.unite(Rectangle4_1)
  Resistor_soldermask_2067 [SolderMask] = rectangle(corner=((board_X/4)-(Resistor_CtoC/2)-Resistor_pad_W-Soldermask_clearance-Soldermask_dam_W, -(board_Y/2)+L_Port1_Trace_2067+2*Radius_2067-(W_70p7_2067 /2)+(W_70p7_2067/4)-(Resistor_pad_H-Resistor_Height)/2-Soldermask_clearance-Soldermask_dam_W, board_Z+copper_thickness), x_size=Soldermask_clearance+Soldermask_dam_W+Resistor_pad_W, y_size=2*(Soldermask_clearance+Soldermask_dam_W)+Resistor_pad_H)
  Rectangle6 = rectangle(corner=((board_X/4)-(Resistor_CtoC/2)-Resistor_pad_W-Soldermask_clearance, -(board_Y/2)+L_Port1_Trace_2067+2*Radius_2067-(W_70p7_2067 /2)+(W_70p7_2067/4)-(Resistor_pad_H-Resistor_Height)/2-Soldermask_clearance, board_Z+copper_thickness), x_size=Soldermask_clearance+Resistor_pad_W, y_size=2*(Soldermask_clearance)+Resistor_pad_H)
  Resistor_soldermask_2067.subtract(Rectangle6)
  Resistor_soldermask_2067.thicken(Solermask_thickness)
  Resistor_soldermask_2246_1 = Resistor_soldermask_2067.duplicate_mirror(point=(board_X/4, 8.0424311mm, 1.6mm), normal=(1mm, 0mm, 0mm))
  Resistor_soldermask_2067.unite(Resistor_soldermask_2246_1)
  Ground_leg_extensions = rectangle(corner=(-board_X/4+3.7465mm, -board_Y /2, -copper_thickness), x_size=1.016mm, y_size=4.2418mm)
  Ground_leg_extensions.thicken(-0.0069mm)
  Ground_leg_extensions_1 = Ground_leg_extensions.duplicate_mirror(point=(-board_X/4, -18mm, 1.6mm), normal=(-1mm, 0mm, 0mm))
  Ground_leg_extensions.unite(Ground_leg_extensions_1)
  732511154 = imported_body(C:\Users\Joshua Wong\Downloads\732511153.x_t)
  732511154.rotate(axis=X, angle=90deg)
  732511154.move(-board_X/4, -board_Y/2-9.525mm, board_Z+copper_thickness+0.3805mm)
  SMA_Dielectric1 [Teflon (tm)] = object_from(?.face(at (-17.5, -18.762, 2.0155)))
  SMA_Dielectric1.sweep_along_vector((0mm, -6.778mm, 0mm))
  732511153_ObjectFromFace1_2 = SMA_Dielectric1.copy()
  732511154.subtract(732511153_ObjectFromFace1_2)
  SMA_Body1 = 732511154.separate_bodies()
  Cylinder2 = cylinder(axis=Y, base_centre=(-board_X/4, -22.14mm, 2.0155mm), radius=0.6477mm, height=-3.4mm)
  732511154.subtract(Cylinder2)
  SMA_Probe1 [copper] = object_from(SMA_Probe1.face(at (-17.5, -22.14, 2.0155)))
  SMA_Probe1.sweep_along_vector((0mm, -3.4mm, 0mm))
  SMA_Probe1.unite(732511154)
  Solder_joint_SMA1 = rectangle(corner=((-board_X/4)-W_50/2, -board_Y/2, board_Z+copper_thickness), x_size=W_50, y_size=Solderblob_H)
  Rectangle7 = rectangle(corner=((-board_X/4)-Center_probe_rad, -board_Y/2, board_Z+copper_thickness+Center_probe_rad), x_size=Center_probe_rad*2, y_size=Center_probe_length)
  Solder_joint_SMA1.connect(Rectangle7)
  Input_Soldermask1 [SolderMask] = rectangle(corner=((-board_X/4)-W_50/2, -board_Y/2+Solderblob_H +Soldermask_clearance, board_Z+copper_thickness), x_size=W_50, y_size=Soldermask_dam_W)
  Input_Soldermask1.thicken(Solermask_thickness)
  Ground_leg_extensions1 = rectangle(corner=(-board_X/4+3.7465mm, -board_Y /2, -copper_thickness), x_size=1.016mm, y_size=4.2418mm)
  Ground_leg_extensions1.thicken(-0.0069mm)
  Ground_leg_extensions_2 = Ground_leg_extensions1.duplicate_mirror(point=(-board_X/4, -18mm, 1.6mm), normal=(-1mm, 0mm, 0mm))
  Ground_leg_extensions1.unite(Ground_leg_extensions_2)
  [SMA_Dielectric1, SMA_Body1, SMA_Probe1, Solder_joint_SMA1, Input_Soldermask1].mirror(point=(0mm, -0.0052562555mm, 0mm), normal=(0mm, 1mm, 0mm))
  [SMA_Dielectric1, SMA_Body1, SMA_Probe1, Solder_joint_SMA1, Input_Soldermask1].move(-(Resistor_CtoC/2)-offset-L_Split*cos(split_angle), 0mm, 0mm)
  732511155 = imported_body(C:\Users\Joshua Wong\Downloads\732511153.x_t)
  732511155.rotate(axis=X, angle=90deg)
  732511155.move(-board_X/4, -board_Y/2-9.525mm, board_Z+copper_thickness+0.3805mm)
  SMA_Dielectric2 [Teflon (tm)] = object_from(?.face(at (-17.5, -18.762, 2.0155)))
  SMA_Dielectric2.sweep_along_vector((0mm, -6.778mm, 0mm))
  732511153_ObjectFromFace1_3 = SMA_Dielectric2.copy()
  SMA_Dielectric2.mirror(point=(0mm, -0.0052562555mm, 0mm), normal=(0mm, 1mm, 0mm))
  SMA_Dielectric2.move(-(Resistor_CtoC/2)-offset-L_Split*cos(split_angle), 0mm, 0mm)
  732511155.subtract(732511153_ObjectFromFace1_3)
  SMA_Body2 = 732511155.separate_bodies()
  SMA_Body2.mirror(point=(0mm, -0.0052562555mm, 0mm), normal=(0mm, 1mm, 0mm))
  SMA_Body2.move(-(Resistor_CtoC/2)-offset-L_Split*cos(split_angle), 0mm, 0mm)
  Cylinder3 = cylinder(axis=Y, base_centre=(-board_X/4, -22.14mm, 2.0155mm), radius=0.6477mm, height=-3.4mm)
  732511155.subtract(Cylinder3)
  SMA_Probe2 [copper] = object_from(SMA_Probe2.face(at (-17.5, -22.14, 2.0155)))
  SMA_Probe2.sweep_along_vector((0mm, -3.4mm, 0mm))
  SMA_Probe2.unite(732511155)
  SMA_Probe2.mirror(point=(0mm, -0.0052562555mm, 0mm), normal=(0mm, 1mm, 0mm))
  SMA_Probe2.move(-(Resistor_CtoC/2)-offset-L_Split*cos(split_angle), 0mm, 0mm)
  Solder_joint_SMA2 = rectangle(corner=((-board_X/4)-W_50/2, -board_Y/2, board_Z+copper_thickness), x_size=W_50, y_size=Solderblob_H)
  Rectangle8 = rectangle(corner=((-board_X/4)-Center_probe_rad, -board_Y/2, board_Z+copper_thickness+Center_probe_rad), x_size=Center_probe_rad*2, y_size=Center_probe_length)
  Solder_joint_SMA2.connect(Rectangle8)
  Solder_joint_SMA2.mirror(point=(0mm, -0.0052562555mm, 0mm), normal=(0mm, 1mm, 0mm))
  Solder_joint_SMA2.move(-(Resistor_CtoC/2)-offset-L_Split*cos(split_angle), 0mm, 0mm)
  Input_Soldermask2 [SolderMask] = rectangle(corner=((-board_X/4)-W_50/2, -board_Y/2+Solderblob_H +Soldermask_clearance, board_Z+copper_thickness), x_size=W_50, y_size=Soldermask_dam_W)
  Input_Soldermask2.thicken(Solermask_thickness)
  Input_Soldermask2.mirror(point=(0mm, -0.0052562555mm, 0mm), normal=(0mm, 1mm, 0mm))
  Input_Soldermask2.move(-(Resistor_CtoC/2)-offset-L_Split*cos(split_angle), 0mm, 0mm)
  Ground_leg_extensions2 = rectangle(corner=(-board_X/4+3.7465mm, -board_Y /2, -copper_thickness), x_size=1.016mm, y_size=4.2418mm)
  Ground_leg_extensions2.thicken(-0.0069mm)
  Ground_leg_extensions_3 = Ground_leg_extensions2.duplicate_mirror(point=(-board_X/4, -18mm, 1.6mm), normal=(-1mm, 0mm, 0mm))
  Ground_leg_extensions2.unite(Ground_leg_extensions_3)
  [SMA_Dielectric2, SMA_Body2, SMA_Probe2, Solder_joint_SMA2, Input_Soldermask2].mirror(point=(-board_X/4, 14mm, 0mm), normal=(1mm, 0mm, 0mm))
  732511156 = imported_body(C:\Users\Joshua Wong\Downloads\732511153.x_t)
  732511156.rotate(axis=X, angle=90deg)
  732511156.move(-board_X/4, -board_Y/2-9.525mm, board_Z+copper_thickness+0.3805mm)
  SMA_Dielectric3 [Teflon (tm)] = object_from(?.face(at (-17.5, -18.762, 2.0155)))
  SMA_Dielectric3.sweep_along_vector((0mm, -6.778mm, 0mm))
  732511153_ObjectFromFace1_4 = SMA_Dielectric3.copy()
  732511156.subtract(732511153_ObjectFromFace1_4)
  SMA_Body3 = 732511156.separate_bodies()
  Cylinder4 = cylinder(axis=Y, base_centre=(-board_X/4, -22.14mm, 2.0155mm), radius=0.6477mm, height=-3.4mm)
  732511156.subtract(Cylinder4)
  SMA_Probe3 [copper] = object_from(SMA_Probe3.face(at (-17.5, -22.14, 2.0155)))
  SMA_Probe3.sweep_along_vector((0mm, -3.4mm, 0mm))
  SMA_Probe3.unite(732511156)
  Solder_joint_SMA3 = rectangle(corner=((-board_X/4)-W_50/2, -board_Y/2, board_Z+copper_thickness), x_size=W_50, y_size=Solderblob_H)
  Rectangle9 = rectangle(corner=((-board_X/4)-Center_probe_rad, -board_Y/2, board_Z+copper_thickness+Center_probe_rad), x_size=Center_probe_rad*2, y_size=Center_probe_length)
  Solder_joint_SMA3.connect(Rectangle9)
  Input_Soldermask3 [SolderMask] = rectangle(corner=((-board_X/4)-W_50/2, -board_Y/2+Solderblob_H +Soldermask_clearance, board_Z+copper_thickness), x_size=W_50, y_size=Soldermask_dam_W)
  Input_Soldermask3.thicken(Solermask_thickness)
  732511157 = imported_body(C:\Users\Joshua Wong\Downloads\732511153.x_t)
  732511157.rotate(axis=X, angle=90deg)
  732511157.move(-board_X/4, -board_Y/2-9.525mm, board_Z+copper_thickness+0.3805mm)
  SMA_Dielectric4 [Teflon (tm)] = object_from(?.face(at (-17.5, -18.762, 2.0155)))
  SMA_Dielectric4.sweep_along_vector((0mm, -6.778mm, 0mm))
  732511153_ObjectFromFace1_5 = SMA_Dielectric4.copy()
  SMA_Dielectric4.mirror(point=(0mm, -0.0052562555mm, 0mm), normal=(0mm, 1mm, 0mm))
  SMA_Dielectric4.move(-(Resistor_CtoC/2)-offset-L_Split*cos(split_angle), 0mm, 0mm)
  732511157.subtract(732511153_ObjectFromFace1_5)
  SMA_Body4 = 732511157.separate_bodies()
  SMA_Body4.mirror(point=(0mm, -0.0052562555mm, 0mm), normal=(0mm, 1mm, 0mm))
  SMA_Body4.move(-(Resistor_CtoC/2)-offset-L_Split*cos(split_angle), 0mm, 0mm)
  Cylinder5 = cylinder(axis=Y, base_centre=(-board_X/4, -22.14mm, 2.0155mm), radius=0.6477mm, height=-3.4mm)
  732511157.subtract(Cylinder5)
  SMA_Probe4 [copper] = object_from(SMA_Probe4.face(at (-17.5, -22.14, 2.0155)))
  SMA_Probe4.sweep_along_vector((0mm, -3.4mm, 0mm))
  SMA_Probe4.unite(732511157)
  SMA_Probe4.mirror(point=(0mm, -0.0052562555mm, 0mm), normal=(0mm, 1mm, 0mm))
  SMA_Probe4.move(-(Resistor_CtoC/2)-offset_2067-L_split_2067*cos(split_angle_2067), 0mm, 0mm)
  Solder_joint_SMA4 = rectangle(corner=((-board_X/4)-W_50/2, -board_Y/2, board_Z+copper_thickness), x_size=W_50, y_size=Solderblob_H)
  Rectangle10 = rectangle(corner=((-board_X/4)-Center_probe_rad, -board_Y/2, board_Z+copper_thickness+Center_probe_rad), x_size=Center_probe_rad*2, y_size=Center_probe_length)
  Solder_joint_SMA4.connect(Rectangle10)
  Solder_joint_SMA4.mirror(point=(0mm, -0.0052562555mm, 0mm), normal=(0mm, 1mm, 0mm))
  Solder_joint_SMA4.move(-(Resistor_CtoC/2)-offset-L_Split*cos(split_angle), 0mm, 0mm)
  Input_Soldermask4 [SolderMask] = rectangle(corner=((-board_X/4)-W_50/2, -board_Y/2+Solderblob_H +Soldermask_clearance, board_Z+copper_thickness), x_size=W_50, y_size=Soldermask_dam_W)
  Input_Soldermask4.thicken(Solermask_thickness)
  Input_Soldermask4.mirror(point=(0mm, -0.0052562555mm, 0mm), normal=(0mm, 1mm, 0mm))
  Input_Soldermask4.move(-(Resistor_CtoC/2)-offset-L_Split*cos(split_angle), 0mm, 0mm)
  732511158 = imported_body(C:\Users\Joshua Wong\Downloads\732511153.x_t)
  732511158.rotate(axis=X, angle=90deg)
  732511158.move(-board_X/4, -board_Y/2-9.525mm, board_Z+copper_thickness+0.3805mm)
  SMA_Dielectric5 [Teflon (tm)] = object_from(?.face(at (-17.5, -18.762, 2.0155)))
  SMA_Dielectric5.sweep_along_vector((0mm, -6.778mm, 0mm))
  732511153_ObjectFromFace1_6 = SMA_Dielectric5.copy()
  SMA_Dielectric5.mirror(point=(0mm, -0.0052562555mm, 0mm), normal=(0mm, 1mm, 0mm))
  SMA_Dielectric5.move(-(Resistor_CtoC/2)-offset-L_Split*cos(split_angle), 0mm, 0mm)
  SMA_Dielectric5.mirror(point=(-board_X/4, 14mm, 0mm), normal=(1mm, 0mm, 0mm))
  732511158.subtract(732511153_ObjectFromFace1_6)
  SMA_Body5 = 732511158.separate_bodies()
  SMA_Body5.mirror(point=(0mm, -0.0052562555mm, 0mm), normal=(0mm, 1mm, 0mm))
  SMA_Body5.move(-(Resistor_CtoC/2)-offset-L_Split*cos(split_angle), 0mm, 0mm)
  SMA_Body5.mirror(point=(-board_X/4, 14mm, 0mm), normal=(1mm, 0mm, 0mm))
  Cylinder6 = cylinder(axis=Y, base_centre=(-board_X/4, -22.14mm, 2.0155mm), radius=0.6477mm, height=-3.4mm)
  732511158.subtract(Cylinder6)
  SMA_Probe5 [copper] = object_from(SMA_Probe5.face(at (-17.5, -22.14, 2.0155)))
  SMA_Probe5.sweep_along_vector((0mm, -3.4mm, 0mm))
  SMA_Probe5.unite(732511158)
  SMA_Probe5.mirror(point=(0mm, -0.0052562555mm, 0mm), normal=(0mm, 1mm, 0mm))
  SMA_Probe5.move(-(Resistor_CtoC/2)-offset-L_Split*cos(split_angle), 0mm, 0mm)
  SMA_Probe5.mirror(point=(-board_X/4, 14mm, 0mm), normal=(1mm, 0mm, 0mm))
  Solder_joint_SMA5 = rectangle(corner=((-board_X/4)-W_50/2, -board_Y/2, board_Z+copper_thickness), x_size=W_50, y_size=Solderblob_H)
  Rectangle11 = rectangle(corner=((-board_X/4)-Center_probe_rad, -board_Y/2, board_Z+copper_thickness+Center_probe_rad), x_size=Center_probe_rad*2, y_size=Center_probe_length)
  Solder_joint_SMA5.connect(Rectangle11)
  Solder_joint_SMA5.mirror(point=(0mm, -0.0052562555mm, 0mm), normal=(0mm, 1mm, 0mm))
  Solder_joint_SMA5.move(-(Resistor_CtoC/2)-offset_2067-L_split_2067*cos(split_angle_2067), 0mm, 0mm)
  Solder_joint_SMA5.mirror(point=(-board_X/4, 14mm, 0mm), normal=(1mm, 0mm, 0mm))
  Input_Soldermask5 [SolderMask] = rectangle(corner=((-board_X/4)-W_50/2, -board_Y/2+Solderblob_H +Soldermask_clearance, board_Z+copper_thickness), x_size=W_50, y_size=Soldermask_dam_W)
  Input_Soldermask5.thicken(Solermask_thickness)
  Input_Soldermask5.mirror(point=(0mm, -0.0052562555mm, 0mm), normal=(0mm, 1mm, 0mm))
  Input_Soldermask5.move(-(Resistor_CtoC/2)-offset-L_Split*cos(split_angle), 0mm, 0mm)
  Input_Soldermask5.mirror(point=(-board_X/4, 14mm, 0mm), normal=(1mm, 0mm, 0mm))
  Ground_leg_extensions3 = rectangle(corner=(-board_X/4+3.7465mm, -board_Y /2, -copper_thickness), x_size=1.016mm, y_size=4.2418mm)
  Ground_leg_extensions3.thicken(-0.0069mm)
  Ground_leg_extensions_4 = Ground_leg_extensions3.duplicate_mirror(point=(-board_X/4, -18mm, 1.6mm), normal=(-1mm, 0mm, 0mm))
  Ground_leg_extensions3.unite(Ground_leg_extensions_4)
  Ground_leg_extensions4 = rectangle(corner=(-board_X/4+3.7465mm, -board_Y /2, -copper_thickness), x_size=1.016mm, y_size=4.2418mm)
  Ground_leg_extensions4.thicken(-0.0069mm)
  Ground_leg_extensions_5 = Ground_leg_extensions4.duplicate_mirror(point=(-board_X/4, -18mm, 1.6mm), normal=(-1mm, 0mm, 0mm))
  Ground_leg_extensions4.unite(Ground_leg_extensions_5)
  Ground_leg_extensions5 = rectangle(corner=(-board_X/4+3.7465mm, -board_Y /2, -copper_thickness), x_size=1.016mm, y_size=4.2418mm)
  Ground_leg_extensions5.thicken(-0.0069mm)
  Ground_leg_extensions_6 = Ground_leg_extensions5.duplicate_mirror(point=(-board_X/4, -18mm, 1.6mm), normal=(-1mm, 0mm, 0mm))
  Ground_leg_extensions5.unite(Ground_leg_extensions_6)
  [SMA_Dielectric3, SMA_Body3, SMA_Probe3, Solder_joint_SMA3, Input_Soldermask3, SMA_Dielectric4, SMA_Body4, SMA_Probe4, Solder_joint_SMA4, Input_Soldermask4, SMA_Dielectric5, SMA_Body5, SMA_Probe5, Solder_joint_SMA5, Input_Soldermask5].mirror(point=(0mm, 0mm, 0mm), normal=(1mm, 0mm, 0mm))
  Circle1 = circle(normal=Y, centre=(-board_X/4, -board_Y/2-7.54mm, 2.015mm), radius=Port_Rad)
  SMA_Dielectric_ObjectFromFace1 = object_from(SMA_Dielectric.face(at (-17.5, -25.54, 2.0155)))
  SMA_Probe_ObjectFromFace1 [copper] = object_from(SMA_Probe.face(at (-17.5, -25.54, 2.0155)))
  SMA_Probe_ObjectFromFace1.unite(SMA_Dielectric_ObjectFromFace1)
  pecCap1 [pec] = sweep_along_normal(SMA_Probe_ObjectFromFace1.face(at (-17.5, -25.54, 2.0155)), length=0.55mm)
  SMA_Dielectric1_ObjectFromFace1 [Teflon (tm)] = object_from(SMA_Dielectric1.face(at (-24.175, 25.5295, 2.0155)))
  SMA_Probe1_ObjectFromFace1 = object_from(SMA_Probe1.face(at (-24.175, 25.5295, 2.0155)))
  SMA_Dielectric1_ObjectFromFace1.unite(SMA_Probe1_ObjectFromFace1)
  pecCap2 [pec] = sweep_along_normal(SMA_Dielectric1_ObjectFromFace1.face(at (-24.175, 25.5295, 2.0155)), length=0.55mm)
  SMA_Dielectric2_ObjectFromFace1 [Teflon (tm)] = object_from(SMA_Dielectric2.face(at (-10.825, 25.5295, 2.0155)))
  SMA_Probe2_ObjectFromFace1 = object_from(SMA_Probe2.face(at (-10.825, 25.5295, 2.0155)))
  SMA_Dielectric2_ObjectFromFace1.unite(SMA_Probe2_ObjectFromFace1)
  pecCap3 [pec] = sweep_along_normal(SMA_Dielectric2_ObjectFromFace1.face(at (-10.825, 25.5295, 2.0155)), length=0.55mm)
  SMA_Dielectric3_ObjectFromFace1 [Teflon (tm)] = object_from(SMA_Dielectric3.face(at (17.5, -25.54, 2.0155)))
  SMA_Probe3_ObjectFromFace1 = object_from(SMA_Probe3.face(at (17.5, -25.54, 2.0155)))
  SMA_Dielectric3_ObjectFromFace1.unite(SMA_Probe3_ObjectFromFace1)
  pecCap4 [pec] = sweep_along_normal(SMA_Dielectric3_ObjectFromFace1.face(at (17.5, -25.54, 2.0155)), length=0.55mm)
  SMA_Dielectric4_ObjectFromFace1 [Teflon (tm)] = object_from(SMA_Dielectric4.face(at (24.175, 25.5295, 2.0155)))
  SMA_Probe4_ObjectFromFace1 = object_from(SMA_Probe4.face(at (24.175, 25.5295, 2.0155)))
  SMA_Dielectric4_ObjectFromFace1.unite(SMA_Probe4_ObjectFromFace1)
  pecCap5 [pec] = sweep_along_normal(SMA_Dielectric4_ObjectFromFace1.face(at (24.175, 25.5295, 2.0155)), length=0.55mm)
  SMA_Dielectric5_ObjectFromFace1 [Teflon (tm)] = object_from(SMA_Dielectric5.face(at (10.825, 25.5295, 2.0155)))
  SMA_Probe5_ObjectFromFace1 = object_from(SMA_Probe5.face(at (10.825, 25.5295, 2.0155)))
  SMA_Dielectric5_ObjectFromFace1.unite(SMA_Probe5_ObjectFromFace1)
  pecCap6 [pec] = sweep_along_normal(SMA_Dielectric5_ObjectFromFace1.face(at (10.825, 25.5295, 2.0155)), length=0.55mm)
  SMA_Probe.unite(Solder_joint_SMA)
  SMA_Probe1.unite(Solder_joint_SMA1)
  SMA_Probe2.unite(Solder_joint_SMA2)
  SMA_Probe4.unite(Solder_joint_SMA4)
  Ground.unite(Ground_leg_extensions, Ground_leg_extensions1..Ground_leg_extensions5)
  Ground.unite(SMA_Body, SMA_Body1..SMA_Body5)
  SMA_Probe5.unite(Solder_joint_SMA5)
  SMA_Probe3.unite(Solder_joint_SMA3)
  group SMA_Port1 = SMA_Dielectric, SMA_Probe, Input_Soldermask, SMA_Probe_ObjectFromFace1, pecCap1
  group SMA_Port2 = SMA_Dielectric1, SMA_Probe1, Input_Soldermask1, SMA_Dielectric1_ObjectFromFace1, pecCap2
  group SMA_Port3 = SMA_Dielectric2, SMA_Probe2, Input_Soldermask2, SMA_Dielectric2_ObjectFromFace1, pecCap3
  group SMA_Port4 = SMA_Dielectric3, SMA_Probe3, Input_Soldermask3, SMA_Dielectric3_ObjectFromFace1, pecCap4
  group SMA_Port5 = SMA_Dielectric4, SMA_Probe4, Input_Soldermask4, SMA_Dielectric4_ObjectFromFace1, pecCap5
  group SMA_Port6 = SMA_Dielectric5, SMA_Probe5, Input_Soldermask5, SMA_Dielectric5_ObjectFromFace1, pecCap6
boundaries and excitations:
  Ground: Perfect E Objects=Ground
  LumpRLC1: Lumped RLC Objects=Resistor_100ohms CurrentLine{(-17.675, 6.3282056, 1.6) -> (-17.325, 6.3282056, 1.6)} RLC_Type=Serial Resistance=100ohm
  Open1: Radiation Objects=RadiatingSurface
  Copper_trace: Perfect E Objects=Copper_trace_2245
  Copper_trace1: Perfect E Objects=Copper_trace_2067
  LumpRLC2: Lumped RLC Objects=Resistor_100ohms_2067 CurrentLine{(17.325, 7.4104592, 1.6) -> (17.675, 7.4104592, 1.6)} RLC_Type=Serial Resistance=100ohm
  Port1_T1: Terminal port=1 Faces=SMA_Probe.face(at (-17.5, -25.54, 2.0155)) TerminalResistance=50ohm
  Port2_T1: Terminal port=2 Faces=SMA_Probe1.face(at (-24.175, 25.5295, 2.0155)) TerminalResistance=50ohm
  Port3_T1: Terminal port=3 Faces=SMA_Probe2.face(at (-10.825, 25.5295, 2.0155)) TerminalResistance=50ohm
  Port4_T1: Terminal port=4 Faces=SMA_Probe3.face(at (17.5, -25.54, 2.0155)) TerminalResistance=50ohm
  Port5_T1: Terminal port=5 Faces=SMA_Probe4.face(at (24.175, 25.5295, 2.0155)) TerminalResistance=50ohm
  Port6_T1: Terminal port=6 Faces=SMA_Probe5.face(at (10.825, 25.5295, 2.0155)) TerminalResistance=50ohm
  1: Wave Port Faces=SMA_Probe_ObjectFromFace1.face(at (-17.5, -25.54, 2.0155)) WavePortType=Terminal NumModes=1
  2: Wave Port Faces=SMA_Dielectric1_ObjectFromFace1.face(at (-24.175, 25.5295, 2.0155)) WavePortType=Terminal NumModes=1
  3: Wave Port Faces=SMA_Dielectric2_ObjectFromFace1.face(at (-10.825, 25.5295, 2.0155)) WavePortType=Terminal NumModes=1
  4: Wave Port Faces=SMA_Dielectric3_ObjectFromFace1.face(at (17.5, -25.54, 2.0155)) WavePortType=Terminal NumModes=1
  5: Wave Port Faces=SMA_Dielectric4_ObjectFromFace1.face(at (24.175, 25.5295, 2.0155)) WavePortType=Terminal NumModes=1
  6: Wave Port Faces=SMA_Dielectric5_ObjectFromFace1.face(at (10.825, 25.5295, 2.0155)) WavePortType=Terminal NumModes=1
  reference conductors: SMA_Body5
setups:
  both_frequencies: HfssDriven Frequency=5GHz MaxDeltaS=0.02 MaximumPasses=20 MinimumPasses=1 MinimumConvergedPasses=1 PercentRefinement=30 BasisOrder=1 PortAccuracy=2 DrivenSolverType="Direct Solver"
    sweep Sweep: 1GHz to 3.5GHz step 10MHz; Type=Interpolating InterpTolerance=0.5 InterpMaxSolns=250 PassivityErrorTolerance=0.0001
source amplitudes:
  1:1: 1V 0deg
  2:1, 3:1, 4:1, 5:1, 6:1: 0V 0deg
optimetrics:
  arc_2067: Parametric Sim._Setups=[both_frequencies]
    sweep quarterwave_2067: LIN 27.7mm 28.7mm 0.2mm
  arc_2245: Parametric Sim._Setups=[both_frequencies]
    sweep quarterwave_2245: LIN 25.8mm 26.6mm 0.2mm
  Dk: Parametric Sim._Setups=[both_frequencies]
    sweep $er_FR4: LIN 4.2 4.8 0.2
radiation setups:
  3D: Infinite Sphere Theta=0deg..180deg step 2deg Phi=-180deg..180deg step 2deg
  Elevation: Infinite Sphere Theta=-180deg..180deg step 1deg Phi=0deg..90deg step 90deg
  Azimuth: Infinite Sphere Theta=90deg..90deg step 0deg Phi=-180deg..180deg step 1deg
reports:
  Terminal S Parameter Plot1: dB(St(Port1_T1,Port1_T1)), dB(St(Port2_T1,Port1_T1)), dB(St(Port3_T1,Port1_T1)), dB(St(Port1_T1,Port2_T1)), dB(St(Port2_T1,Port2_T1)), dB(St(Port3_T1,Port2_T1)), dB(St(Port1_T1,Port3_T1)), dB(St(Port2_T1,Port3_T1)), dB(St(Port3_T1,Port3_T1)) vs Freq on both_frequencies : Sweep [$er_FR4=4.4]; markers MX1 at x=2.2447479e+09
  Terminal S Parameter Plot2: dB(St(Port4_T1,Port4_T1)), dB(St(Port5_T1,Port4_T1)), dB(St(Port6_T1,Port4_T1)), dB(St(Port4_T1,Port5_T1)), dB(St(Port5_T1,Port5_T1)), dB(St(Port6_T1,Port5_T1)), dB(St(Port4_T1,Port6_T1)), dB(St(Port5_T1,Port6_T1)), dB(St(Port6_T1,Port6_T1)) vs Freq on both_frequencies : Sweep [$er_FR4=4.4]; markers MX1 at x=2.0674895e+09
  Terminal S Parameter Plot3: dB(St(Port6_T1,Port3_T1)) vs Freq on both_frequencies : Sweep

design Wilkinson_V6 (HFSS, HFSS Terminal Network, model units mm)
options: Allow_Material_Override
variables:
  board_X = 70mm
  board_Y = 36mm
  board_Z = 1.6mm
  W_50 = 2.92mm  # 50 Ohm trace width
  L_Port1_Trace = 8mm  # Port 1 trace length
  W_70p7 = 1.45mm  # 70.7 Ohm trace width
  Resistor_CtoC = 0.35mm  # 0603 footprint copper to copper distance
  quarterwave_2245 = 24.7mm
  Radius = (quarterwave_2245-(Resistor_CtoC/2))/pi
  turn_radius = 5mm
  L_Split = 7mm
  offset = 3.5mm
  split_angle = 30deg  # Angle from X-axis to diagonal trace
  fillet_radius = 1.5mm
  W_50_2067 = 2.92mm
  L_Port1_Trace_2067 = 8mm
  W_70p7_2067 = 1.45mm
  quarterwave_2067 = 26mm
  Radius_2067 = (quarterwave_2067-(Resistor_CtoC/2))/pi
  L_split_2067 = 7mm
  offset_2067 = 3.5mm
  split_angle_2067 = 30deg
  copper_thickness = 0.035mm
  er_FR4 = 4.5
  SMA_Pad_W = 2.415mm
  SMA_Pad_H = 5.84mm
  SMA_Pad_Separation = 8.765mm
  Resistor_Height = 0.5mm
  Via_Radius = 0.15mm
  Via_edge_spacing = 1.2mm
  Via_center_spacing = 1.2mm
  Via_quantity = 3
  Resistor_pad_W = 0.45mm
  Resistor_pad_H = 0.6mm
  Solderblob_H = 5.4mm
  Center_probe_rad = 0.38mm
  Center_probe_length = 4.75mm
  Soldermask_clearance = 0.075mm
  Soldermask_dam_W = 0.2mm
  Solermask_thickness = 0.02mm
  Port_Rad = 2.1081331mm
  L_parallel = 1mm
  fillet_radius_small = 0.2mm
geometry:
  Ground [copper] = rectangle(corner=(-board_X/2, -board_Y/2, 0mm), x_size=board_X, y_size=board_Y)
  Substrate [FR4_epoxy_Wilkinson] = box(corner=(-board_X/2, -board_Y/2, 0mm), size=(board_X, board_Y, board_Z))
  Copper_trace_2245 [copper] = rectangle(corner=(-(board_X/4)-(W_50/2), -board_Y/2, 1.6mm), x_size=W_50, y_size=L_Port1_Trace)
  Stub_1 = rectangle(corner=(-(board_X/4)-(Resistor_CtoC/2), -(board_Y/2)+L_Port1_Trace-(W_70p7/2), board_Z), x_size=Resistor_CtoC/2, y_size=W_70p7)
  Stub_2 = rectangle(corner=(-(board_X/4), -(board_Y/2)+L_Port1_Trace-(W_70p7/2), board_Z), x_size=Resistor_CtoC/2, y_size=W_70p7)
  Arc_1_Line = polyline((-(board_X/4)-(Resistor_CtoC/2), -(board_Y/2)+L_Port1_Trace, board_Z) (-25.48155mm, -2.19345mm, 1.6mm) (-17.675mm, 5.6130999mm, 1.6mm), AngularArc from point 0 over 3 centre=(-(board_X/4)-(Resistor_CtoC/2), -(board_Y/2)+L_Port1_Trace+Radius, board_Z) angle=-180deg plane=XY)
  Arc_1_Line1 = polyline((-(board_X/4)+(Resistor_CtoC/2), -(board_Y/2)+L_Port1_Trace, board_Z) (-9.51845mm, -2.19345mm, 1.6mm) (-17.325mm, 5.6130999mm, 1.6mm), AngularArc from point 0 over 3 centre=(-(board_X/4)+(Resistor_CtoC/2), -(board_Y/2)+L_Port1_Trace+Radius, board_Z) angle=180deg plane=XY)
  Arc_1 = polyline((-(board_X/4)-(Resistor_CtoC/2), -(board_Y/2)+L_Port1_Trace-(W_70p7/2), board_Z) (-(board_X/4)-(Resistor_CtoC/2), -(board_Y/2)+L_Port1_Trace+(W_70p7/2), board_Z))
  Arc_1.sweep_along_path(Arc_1_Line)
  Arc_2 = polyline((-(board_X/4)+(Resistor_CtoC/2), -(board_Y/2)+L_Port1_Trace-(W_70p7/2), board_Z) (-(board_X/4)+(Resistor_CtoC/2), -(board_Y/2)+L_Port1_Trace+(W_70p7/2), board_Z))
  Arc_2.sweep_along_path(Arc_1_Line1)
  Resistor_100ohms = rectangle(corner=(-(board_X/4)-(Resistor_CtoC/2), -(board_Y/2)+L_Port1_Trace+2*Radius-(W_70p7 /2)+(W_70p7/4), board_Z), x_size=Resistor_CtoC, y_size=Resistor_Height)
  RadiatingSurface [vacuum] = region(absolute_offset=44.54343mm on all sides)
  Copper_trace_2067 [copper] = rectangle(corner=(-(board_X/4)-(W_50_2067/2), -board_Y/2, board_Z), x_size=W_50_2067, y_size=L_Port1_Trace_2067)
  Stub_3 = rectangle(corner=(-(board_X/4)-(Resistor_CtoC/2), -(board_Y/2)+L_Port1_Trace_2067-(W_70p7_2067/2), board_Z), x_size=Resistor_CtoC/2, y_size=W_70p7_2067)
  Stub_4 = rectangle(corner=(-(board_X/4), -(board_Y/2)+L_Port1_Trace_2067-(W_70p7_2067/2), board_Z), x_size=Resistor_CtoC/2, y_size=W_70p7_2067)
  Arc_1_Line2 = polyline((-(board_X/4)-(Resistor_CtoC/2), -(board_Y/2)+L_Port1_Trace_2067, board_Z) (-25.895353mm, -1.7796472mm, 1.6mm) (-17.675mm, 6.4407056mm, 1.6mm), AngularArc from point 0 over 3 centre=(-(board_X/4)-(Resistor_CtoC/2), -(board_Y/2)+L_Port1_Trace_2067+Radius_2067, board_Z) angle=-180deg plane=XY)
  Arc_1_Line3 = polyline((-(board_X/4)+(Resistor_CtoC/2), -(board_Y/2)+L_Port1_Trace_2067, board_Z) (-9.1046472mm, -1.7796472mm, 1.6mm) (-17.325mm, 6.4407056mm, 1.6mm), AngularArc from point 0 over 3 centre=(-(board_X/4)+(Resistor_CtoC/2), -(board_Y/2)+L_Port1_Trace_2067+Radius_2067, board_Z) angle=180deg plane=XY)
  Arc_3 = polyline((-(board_X/4)-(Resistor_CtoC/2), -(board_Y/2)+L_Port1_Trace_2067-(W_70p7_2067/2), board_Z) (-(board_X/4)-(Resistor_CtoC/2), -(board_Y/2)+L_Port1_Trace_2067+(W_70p7_2067/2), board_Z))
  Arc_3.sweep_along_path(Arc_1_Line2)
  Arc_4 = polyline((-(board_X/4)+(Resistor_CtoC/2), -(board_Y/2)+L_Port1_Trace_2067-(W_70p7_2067/2), board_Z) (-(board_X/4)+(Resistor_CtoC/2), -(board_Y/2)+L_Port1_Trace_2067+(W_70p7_2067/2), board_Z))
  Arc_4.sweep_along_path(Arc_1_Line3)
  Resistor_100ohms_2067 = rectangle(corner=((board_X/4)-(Resistor_CtoC/2), -(board_Y/2)+L_Port1_Trace_2067+2*Radius_2067-(W_70p7_2067/2)+(W_70p7_2067/4), board_Z), x_size=Resistor_CtoC, y_size=Resistor_Height)
  Ground.thicken(-copper_thickness)
  Pad1 = rectangle(corner=(-(board_X/4)-(SMA_Pad_Separation/2)-(SMA_Pad_W/2), -board_Y/2, board_Z), x_size=SMA_Pad_W, y_size=SMA_Pad_H)
  Pad1.thicken(copper_thickness)
  Pad2 = Pad1.duplicate_mirror(point=(-board_X/4, -18mm, 1.635mm), normal=(-1mm, 0mm, 0mm))
  Vias_Pad1 = cylinder(axis=Z, base_centre=(-(board_X/4)-(SMA_Pad_Separation/2), -board_Y/2+Via_edge_spacing, 0), radius=Via_Radius, height=board_Z)
  Vias_Pad1.duplicate_along_line(step=(0mm, Via_center_spacing, 0mm), total=Via_quantity, attached)
  Vias_Pad2 = Vias_Pad1.duplicate_mirror(point=(-board_X/4, -18mm, 1.635mm), normal=(1mm, 0mm, 0mm))
  732511153 = imported_body(C:\Users\Joshua Wong\Downloads\732511153.x_t)
  732511153.rotate(axis=X, angle=90deg)
  732511153.move(-board_X/4, -board_Y/2-9.525mm, board_Z+copper_thickness+0.3805mm)
  SMA_Dielectric [Teflon (tm)] = object_from(?.face(at (-17.5, -18.762, 2.0155)))
  SMA_Dielectric.sweep_along_vector((0mm, -6.778mm, 0mm))
  732511153_ObjectFromFace1_1 = SMA_Dielectric.copy()
  732511153.subtract(732511153_ObjectFromFace1_1)
  SMA_Body = 732511153.separate_bodies()
  Cylinder1 = cylinder(axis=Y, base_centre=(-board_X/4, -board_Y/2-4.14mm, 2.0155mm), radius=0.6477mm, height=-3.4mm)
  732511153.subtract(Cylinder1)
  SMA_Probe [copper] = object_from(SMA_Probe.face(at (-17.5, -22.14, 2.0155)))
  SMA_Probe.sweep_along_vector((0mm, -3.4mm, 0mm))
  SMA_Probe.unite(732511153)
  Resistor_pad_outline_2245 = rectangle(corner=(-(board_X/4)-(Resistor_CtoC/2)-Resistor_pad_W, -(board_Y/2)+L_Port1_Trace+2*Radius-(W_70p7 /2)+(W_70p7/4)-(Resistor_pad_H-Resistor_Height)/2, board_Z+copper_thickness), x_size=Resistor_pad_W, y_size=Resistor_pad_H)
  Rectangle1_1 = Resistor_pad_outline_2245.duplicate_mirror(point=(-board_X/4, 6.8328535mm, 1.6mm), normal=(1mm, 0mm, 0mm))
  Resistor_pad_outline_2245.unite(Rectangle1_1)
  Resistor_pad_outline_2067 = rectangle(corner=((board_X/4)-(Resistor_CtoC/2) -Resistor_pad_W, -(board_Y/2)+L_Port1_Trace_2067+2*Radius_2067-(W_70p7_2067/2)+(W_70p7_2067/4)-(Resistor_pad_H-Resistor_Height)/2, board_Z+copper_thickness), x_size=Resistor_pad_W, y_size=Resistor_pad_H)
  Rectangle1_2 = Resistor_pad_outline_2067.duplicate_mirror(point=(board_X/4, 8.0424311mm, 1.6mm), normal=(1mm, 0mm, 0mm))
  Resistor_pad_outline_2067.unite(Rectangle1_2)
  Solder_joint_SMA = rectangle(corner=((-board_X/4)-W_50/2, -board_Y/2, board_Z+copper_thickness), x_size=W_50, y_size=Solderblob_H)
  Rectangle2 = rectangle(corner=((-board_X/4)-Center_probe_rad, -board_Y/2, board_Z+copper_thickness+Center_probe_rad), x_size=Center_probe_rad*2, y_size=Center_probe_length)
  Solder_joint_SMA.connect(Rectangle2)
  Input_Soldermask [SolderMask] = rectangle(corner=((-board_X/4)-W_50/2, -board_Y/2+Solderblob_H +Soldermask_clearance, board_Z+copper_thickness), x_size=W_50, y_size=Soldermask_dam_W)
  Input_Soldermask.thicken(Solermask_thickness)
  Resistor_soldermask_2245 [SolderMask] = rectangle(corner=(-(board_X/4)-(Resistor_CtoC/2)-Resistor_pad_W-Soldermask_clearance-Soldermask_dam_W, -(board_Y/2)+L_Port1_Trace+2*Radius-(W_70p7 /2)+(W_70p7/4)-(Resistor_pad_H-Resistor_Height)/2-Soldermask_clearance-Soldermask_dam_W, board_Z+copper_thickness), x_size=Soldermask_clearance+Soldermask_dam_W+Resistor_pad_W, y_size=2*(Soldermask_clearance+Soldermask_dam_W)+Resistor_pad_H)
  Rectangle5 = rectangle(corner=(-(board_X/4)-(Resistor_CtoC/2)-Resistor_pad_W-Soldermask_clearance, -(board_Y/2)+L_Port1_Trace+2*Radius-(W_70p7 /2)+(W_70p7/4)-(Resistor_pad_H-Resistor_Height)/2-Soldermask_clearance, board_Z+copper_thickness), x_size=Soldermask_clearance+Resistor_pad_W, y_size=2*(Soldermask_clearance)+Resistor_pad_H)
  Resistor_soldermask_2245.subtract(Rectangle5)
  Resistor_soldermask_2245.thicken(Solermask_thickness)
  Rectangle4_1 = Resistor_soldermask_2245.duplicate_mirror(point=(-board_X/4, 6.8328535mm, 1.6mm), normal=(1mm, 0mm, 0mm))
  Resistor_soldermask_2245.unite(Rectangle4_1)
  Resistor_soldermask_2067 [SolderMask] = rectangle(corner=((board_X/4)-(Resistor_CtoC/2)-Resistor_pad_W-Soldermask_clearance-Soldermask_dam_W, -(board_Y/2)+L_Port1_Trace_2067+2*Radius_2067-(W_70p7_2067 /2)+(W_70p7_2067/4)-(Resistor_pad_H-Resistor_Height)/2-Soldermask_clearance-Soldermask_dam_W, board_Z+copper_thickness), x_size=Soldermask_clearance+Soldermask_dam_W+Resistor_pad_W, y_size=2*(Soldermask_clearance+Soldermask_dam_W)+Resistor_pad_H)
  Rectangle6 = rectangle(corner=((board_X/4)-(Resistor_CtoC/2)-Resistor_pad_W-Soldermask_clearance, -(board_Y/2)+L_Port1_Trace_2067+2*Radius_2067-(W_70p7_2067 /2)+(W_70p7_2067/4)-(Resistor_pad_H-Resistor_Height)/2-Soldermask_clearance, board_Z+copper_thickness), x_size=Soldermask_clearance+Resistor_pad_W, y_size=2*(Soldermask_clearance)+Resistor_pad_H)
  Resistor_soldermask_2067.subtract(Rectangle6)
  Resistor_soldermask_2067.thicken(Solermask_thickness)
  Resistor_soldermask_2246_1 = Resistor_soldermask_2067.duplicate_mirror(point=(board_X/4, 8.0424311mm, 1.6mm), normal=(1mm, 0mm, 0mm))
  Resistor_soldermask_2067.unite(Resistor_soldermask_2246_1)
  Ground_leg_extensions = rectangle(corner=(-board_X/4+3.7465mm, -board_Y /2, -copper_thickness), x_size=1.016mm, y_size=4.2418mm)
  Ground_leg_extensions.thicken(-0.0069mm)
  Ground_leg_extensions_1 = Ground_leg_extensions.duplicate_mirror(point=(-board_X/4, -18mm, 1.6mm), normal=(-1mm, 0mm, 0mm))
  Ground_leg_extensions.unite(Ground_leg_extensions_1)
  732511154 = imported_body(C:\Users\Joshua Wong\Downloads\732511153.x_t)
  732511154.rotate(axis=X, angle=90deg)
  732511154.move(-board_X/4, -board_Y/2-9.525mm, board_Z+copper_thickness+0.3805mm)
  SMA_Dielectric1 = object_from(?.face(at (-17.5, -18.762, 2.0155)))
  SMA_Dielectric1.sweep_along_vector((0mm, -6.778mm, 0mm))
  732511153_ObjectFromFace1_2 = SMA_Dielectric1.copy()
  732511154.subtract(732511153_ObjectFromFace1_2)
  SMA_Body1 = 732511154.separate_bodies()
  732511154.delete()
  Ground_leg_extensions1 = rectangle(corner=(-board_X/4+3.7465mm, -board_Y /2, -copper_thickness), x_size=1.016mm, y_size=4.2418mm)
  Ground_leg_extensions1.thicken(-0.0069mm)
  Ground_leg_extensions_2 = Ground_leg_extensions1.duplicate_mirror(point=(-board_X/4, -18mm, 1.6mm), normal=(-1mm, 0mm, 0mm))
  Ground_leg_extensions1.unite(Ground_leg_extensions_2)
  [SMA_Dielectric1, SMA_Body1].mirror(point=(0mm, -0.0052562555mm, 0mm), normal=(0mm, 1mm, 0mm))
  SMA_Dielectric1.move(-(Resistor_CtoC/2)-offset-L_Split*cos(split_angle), 0mm, 0mm)
  SMA_Dielectric1.delete()
  SMA_Body1.move(-(Resistor_CtoC/2)- (W_50/2)*sin(split_angle) -L_Split*cos(split_angle), 0mm, 0mm)
  732511155 = imported_body(C:\Users\Joshua Wong\Downloads\732511153.x_t)
  732511155.rotate(axis=X, angle=90deg)
  732511155.move(-board_X/4, -board_Y/2-9.525mm, board_Z+copper_thickness+0.3805mm)
  SMA_Dielectric2 = object_from(?.face(at (-17.5, -18.762, 2.0155)))
  SMA_Dielectric2.sweep_along_vector((0mm, -6.778mm, 0mm))
  732511153_ObjectFromFace1_3 = SMA_Dielectric2.copy()
  SMA_Dielectric2.mirror(point=(0mm, -0.0052562555mm, 0mm), normal=(0mm, 1mm, 0mm))
  SMA_Dielectric2.move(-(Resistor_CtoC/2)-offset-L_Split*cos(split_angle), 0mm, 0mm)
  732511155.subtract(732511153_ObjectFromFace1_3)
  SMA_Body2 = 732511155.separate_bodies()
  732511155.delete()
  SMA_Body2.mirror(point=(0mm, -0.0052562555mm, 0mm), normal=(0mm, 1mm, 0mm))
  SMA_Body2.move(-(Resistor_CtoC/2)- (W_50/2)*sin(split_angle) -L_Split*cos(split_angle), 0mm, 0mm)
  Ground_leg_extensions2 = rectangle(corner=(-board_X/4+3.7465mm, -board_Y /2, -copper_thickness), x_size=1.016mm, y_size=4.2418mm)
  Ground_leg_extensions2.thicken(-0.0069mm)
  Ground_leg_extensions_3 = Ground_leg_extensions2.duplicate_mirror(point=(-board_X/4, -18mm, 1.6mm), normal=(-1mm, 0mm, 0mm))
  Ground_leg_extensions2.unite(Ground_leg_extensions_3)
  SMA_Dielectric2.mirror(point=(-board_X/4, 14mm, 0mm), normal=(1mm, 0mm, 0mm))
  SMA_Dielectric2.delete()
  SMA_Body2.mirror(point=(-board_X/4, 14mm, 0mm), normal=(1mm, 0mm, 0mm))
  Ground_leg_extensions3 = rectangle(corner=(-board_X/4+3.7465mm, -board_Y /2, -copper_thickness), x_size=1.016mm, y_size=4.2418mm)
  Ground_leg_extensions3.thicken(-0.0069mm)
  Ground_leg_extensions_4 = Ground_leg_extensions3.duplicate_mirror(point=(-board_X/4, -18mm, 1.6mm), normal=(-1mm, 0mm, 0mm))
  Ground_leg_extensions3.unite(Ground_leg_extensions_4)
  Ground_leg_extensions4 = rectangle(corner=(-board_X/4+3.7465mm, -board_Y /2, -copper_thickness), x_size=1.016mm, y_size=4.2418mm)
  Ground_leg_extensions4.thicken(-0.0069mm)
  Ground_leg_extensions_5 = Ground_leg_extensions4.duplicate_mirror(point=(-board_X/4, -18mm, 1.6mm), normal=(-1mm, 0mm, 0mm))
  Ground_leg_extensions4.unite(Ground_leg_extensions_5)
  Ground_leg_extensions5 = rectangle(corner=(-board_X/4+3.7465mm, -board_Y /2, -copper_thickness), x_size=1.016mm, y_size=4.2418mm)
  Ground_leg_extensions5.thicken(-0.0069mm)
  Ground_leg_extensions_6 = Ground_leg_extensions5.duplicate_mirror(point=(-board_X/4, -18mm, 1.6mm), normal=(-1mm, 0mm, 0mm))
  Ground_leg_extensions5.unite(Ground_leg_extensions_6)
  SMA_Probe.unite(Solder_joint_SMA)
  Ground.unite(Ground_leg_extensions, Ground_leg_extensions1..Ground_leg_extensions5)
  732511156 = imported_body(C:\Users\Joshua Wong\Downloads\732511153.x_t)
  732511156.rotate(axis=X, angle=90deg)
  732511156.move(-board_X/4, -board_Y/2-9.525mm, board_Z+copper_thickness+0.3805mm)
  SMA_Dielectric3 = object_from(?.face(at (-17.5, -18.762, 2.0155)))
  SMA_Dielectric3.sweep_along_vector((0mm, -6.778mm, 0mm))
  732511153_ObjectFromFace1_4 = SMA_Dielectric3.copy()
  732511156.subtract(732511153_ObjectFromFace1_4)
  SMA_Body3 = 732511156.separate_bodies()
  732511156.delete()
  SMA_Dielectric3.mirror(point=(0mm, 0mm, 0mm), normal=(1mm, 0mm, 0mm))
  SMA_Dielectric3.delete()
  SMA_Body3.mirror(point=(0mm, 0mm, 0mm), normal=(1mm, 0mm, 0mm))
  732511157 = imported_body(C:\Users\Joshua Wong\Downloads\732511153.x_t)
  732511157.rotate(axis=X, angle=90deg)
  732511157.move(-board_X/4, -board_Y/2-9.525mm, board_Z+copper_thickness+0.3805mm)
  SMA_Dielectric4 = object_from(?.face(at (-17.5, -18.762, 2.0155)))
  SMA_Dielectric4.sweep_along_vector((0mm, -6.778mm, 0mm))
  732511153_ObjectFromFace1_5 = SMA_Dielectric4.copy()
  SMA_Dielectric4.mirror(point=(0mm, 0mm, 0mm), normal=(1mm, 0mm, 0mm))
  732511157.subtract(732511153_ObjectFromFace1_5)
  SMA_Body4 = 732511157.separate_bodies()
  732511157.delete()
  SMA_Body4.mirror(point=(0mm, 0mm, 0mm), normal=(1mm, 0mm, 0mm))
  [SMA_Dielectric4, SMA_Body4].mirror(point=(0mm, 0mm, 0mm), normal=(0mm, 1mm, 0mm))
  SMA_Dielectric4.move(-(Resistor_CtoC/2)-offset_2067-L_Split_2067*cos(split_angle_2067), 0mm, 0mm)
  SMA_Dielectric4.delete()
  SMA_Body4.move(-(Resistor_CtoC/2)- (W_50_2067/2)*sin(split_angle_2067) -L_split_2067*cos(split_angle_2067), 0mm, 0mm)
  732511158 = imported_body(C:\Users\Joshua Wong\Downloads\732511153.x_t)
  732511158.rotate(axis=X, angle=90deg)
  732511158.move(-board_X/4, -board_Y/2-9.525mm, board_Z+copper_thickness+0.3805mm)
  SMA_Dielectric5 = object_from(?.face(at (-17.5, -18.762, 2.0155)))
  SMA_Dielectric5.sweep_along_vector((0mm, -6.778mm, 0mm))
  732511153_ObjectFromFace1_6 = SMA_Dielectric5.copy()
  SMA_Dielectric5.mirror(point=(0mm, 0mm, 0mm), normal=(1mm, 0mm, 0mm))
  SMA_Dielectric5.mirror(point=(0mm, 0mm, 0mm), normal=(0mm, 1mm, 0mm))
  SMA_Dielectric5.move(-(Resistor_CtoC/2)-offset_2067-L_Split_2067*cos(split_angle_2067), 0mm, 0mm)
  732511158.subtract(732511153_ObjectFromFace1_6)
  SMA_Body5 = 732511158.separate_bodies()
  732511158.delete()
  SMA_Body5.mirror(point=(0mm, 0mm, 0mm), normal=(1mm, 0mm, 0mm))
  SMA_Body5.mirror(point=(0mm, 0mm, 0mm), normal=(0mm, 1mm, 0mm))
  SMA_Body5.move(-(Resistor_CtoC/2)- (W_50_2067/2)*sin(split_angle_2067) -L_split_2067*cos(split_angle_2067), 0mm, 0mm)
  SMA_Dielectric5.mirror(point=(board_X/4, 0mm, 0mm), normal=(1mm, 0mm, 0mm))
  SMA_Dielectric5.delete()
  SMA_Body5.mirror(point=(board_X/4, 0mm, 0mm), normal=(1mm, 0mm, 0mm))
  SMA_Dielectric_ObjectFromFace1 [Teflon (tm)] = object_from(SMA_Dielectric.face(at (-17.5, -25.54, 2.0155)))
  SMA_Probe_ObjectFromFace1 = object_from(SMA_Probe.face(at (-17.5, -25.54, 2.0155)))
  SMA_Dielectric_ObjectFromFace1.unite(SMA_Probe_ObjectFromFace1)
  pecCap1 [pec] = sweep_along_normal(SMA_Dielectric_ObjectFromFace1.face(at (-17.5, -25.54, 2.0155)), length=0.55mm)
  Polyline13 = polyline((-(board_X/4)-(Resistor_CtoC/2), -(board_Y/2)+L_Port1_Trace+2*Radius+W_70p7/2, board_Z) (-(board_X/4)-(Resistor_CtoC/2)-W_50*sin(split_angle), -(board_Y/2)+L_Port1_Trace+2*Radius+W_70p7/2- W_50*cos(split_angle), board_Z))
  Polyline14 = polyline((-(board_X/4)-(Resistor_CtoC/2)- (W_50/2)*sin(split_angle), -(board_Y/2)+L_Port1_Trace+2*Radius+W_70p7/2- (W_50/2)*cos(split_angle), board_Z) (-(board_X/4)-(Resistor_CtoC/2)- (W_50/2)*sin(split_angle) -L_Split*cos(split_angle), -(board_Y/2)+L_Port1_Trace+2*Radius+W_70p7/2- (W_50/2)*cos(split_angle)+L_Split*sin(split_angle), board_Z))
  Polyline15 = polyline((-(board_X/4)-(Resistor_CtoC/2)- (W_50/2)*sin(split_angle) -L_Split*cos(split_angle), -(board_Y/2)+L_Port1_Trace+2*Radius+W_70p7/2- (W_50/2)*cos(split_angle)+L_Split*sin(split_angle), board_Z) (-(board_X/4)-(Resistor_CtoC/2)- (W_50/2)*sin(split_angle) -L_Split*cos(split_angle), board_Y/2, board_Z))
  Circle1 = circle(normal=Z, centre=(-(board_X/4)-(Resistor_CtoC/2), -(board_Y/2)+L_Port1_Trace+Radius, board_Z), radius=Radius-W_70p7/2)
  Polyline14.unite(Polyline15)
  Polyline13.sweep_along_path(Polyline14)
  Polyline13.subtract(Circle1)
  Polyline13_1 = Polyline13.duplicate_mirror(point=(-board_X/4, 4.8328535mm, 1.6mm), normal=(1mm, 0mm, 0mm))
  Copper_trace_2245.unite(Polyline13_1, Polyline13, Arc_2, Arc_1, Stub_1, Stub_2)
  Polyline16 = polyline((-(board_X/4)-(Resistor_CtoC/2), -(board_Y/2)+L_Port1_Trace_2067+2*Radius_2067 +W_70p7_2067/2, board_Z) (-(board_X/4)-(Resistor_CtoC/2)-(W_50_2067)*sin(split_angle_2067), -(board_Y/2)+L_Port1_Trace_2067+2*Radius_2067 +W_70p7_2067/2-(W_50_2067)*cos(split_angle_2067), board_Z))
  Polyline17 = polyline((-(board_X/4)-(Resistor_CtoC/2)-(W_50_2067/2)*sin(split_angle_2067), -(board_Y/2)+L_Port1_Trace_2067+2*Radius_2067 +W_70p7_2067/2-(W_50_2067/2)*cos(split_angle_2067), board_Z) (-(board_X/4)-(Resistor_CtoC/2)-(W_50_2067/2)*sin(split_angle_2067)-L_split_2067*cos(split_angle_2067), -(board_Y/2)+L_Port1_Trace_2067+2*Radius_2067 +W_70p7_2067/2-(W_50_2067/2)*cos(split_angle_2067)+L_split_2067*sin(split_angle_2067), board_Z))
  Polyline18 = polyline((-(board_X/4)-(Resistor_CtoC/2)-(W_50_2067/2)*sin(split_angle_2067)-L_split_2067*cos(split_angle_2067), -(board_Y/2)+L_Port1_Trace_2067+2*Radius_2067 +W_70p7_2067/2-(W_50_2067/2)*cos(split_angle_2067)+L_split_2067*sin(split_angle_2067), board_Z) (-(board_X/4)-(Resistor_CtoC/2)-(W_50_2067/2)*sin(split_angle_2067)-L_split_2067*cos(split_angle_2067), (board_Y/2), board_Z))
  Polyline17.unite(Polyline18)
  Polyline16.sweep_along_path(Polyline17)
  Circle2 = circle(normal=Z, centre=(-(board_X/4)-(Resistor_CtoC/2), -(board_Y/2)+L_Port1_Trace_2067+Radius_2067, board_Z), radius=Radius_2067-W_70p7_2067/2)
  Polyline16.subtract(Circle2)
  Polyline16_1 = Polyline16.duplicate_mirror(point=(-board_X/4, 4.8328535mm, 1.6mm), normal=(1mm, 0mm, 0mm))
  Copper_trace_2067.unite(Stub_3, Stub_4, Polyline16, Polyline16_1, Arc_4, Arc_3)
  Copper_trace_2067.mirror(point=(0mm, 0mm, 0mm), normal=(1mm, 0mm, 0mm))
  Ground.unite(SMA_Body5, SMA_Body4, SMA_Body3, SMA_Body2, SMA_Body1, SMA_Body)
  Pad3 = rectangle(corner=(-(board_X/4)-(SMA_Pad_Separation/2)-(SMA_Pad_W/2), -board_Y/2, board_Z), x_size=SMA_Pad_W, y_size=SMA_Pad_H)
  Pad3.thicken(copper_thickness)
  Pad4 = Pad3.duplicate_mirror(point=(-board_X/4, -18mm, 1.635mm), normal=(-1mm, 0mm, 0mm))
  Vias_Pad3 = cylinder(axis=Z, base_centre=(-(board_X/4)-(SMA_Pad_Separation/2), -board_Y/2+Via_edge_spacing, 0), radius=Via_Radius, height=board_Z)
  Vias_Pad3.duplicate_along_line(step=(0mm, Via_center_spacing, 0mm), total=Via_quantity, attached)
  Vias_Pad4 = Vias_Pad3.duplicate_mirror(point=(-board_X/4, -18mm, 1.635mm), normal=(1mm, 0mm, 0mm))
  [Pad3, Pad4, Vias_Pad3, Vias_Pad4].mirror(point=(0mm, 0mm, 0mm), normal=(0mm, 1mm, 0mm))
  [Pad3, Pad4, Vias_Pad3, Vias_Pad4].move(-(Resistor_CtoC/2)- (W_50/2)*sin(split_angle) -L_Split*cos(split_angle), 0mm, 0mm)
  Pad5 = rectangle(corner=(-(board_X/4)-(SMA_Pad_Separation/2)-(SMA_Pad_W/2), -board_Y/2, board_Z), x_size=SMA_Pad_W, y_size=SMA_Pad_H)
  Pad5.thicken(copper_thickness)
  Pad6 = Pad5.duplicate_mirror(point=(-board_X/4, -18mm, 1.635mm), normal=(-1mm, 0mm, 0mm))
  Pad5.mirror(point=(0mm, 0mm, 0mm), normal=(0mm, 1mm, 0mm))
  Pad5.move(-(Resistor_CtoC/2)- (W_50/2)*sin(split_angle) -L_Split*cos(split_angle), 0mm, 0mm)
  Pad6.mirror(point=(0mm, 0mm, 0mm), normal=(0mm, 1mm, 0mm))
  Pad6.move(-(Resistor_CtoC/2)- (W_50/2)*sin(split_angle) -L_Split*cos(split_angle), 0mm, 0mm)
  Vias_Pad5 = cylinder(axis=Z, base_centre=(-(board_X/4)-(SMA_Pad_Separation/2), -board_Y/2+Via_edge_spacing, 0), radius=Via_Radius, height=board_Z)
  Vias_Pad5.duplicate_along_line(step=(0mm, Via_center_spacing, 0mm), total=Via_quantity, attached)
  Vias_Pad6 = Vias_Pad5.duplicate_mirror(point=(-board_X/4, -18mm, 1.635mm), normal=(1mm, 0mm, 0mm))
  Vias_Pad5.mirror(point=(0mm, 0mm, 0mm), normal=(0mm, 1mm, 0mm))
  Vias_Pad5.move(-(Resistor_CtoC/2)- (W_50/2)*sin(split_angle) -L_Split*cos(split_angle), 0mm, 0mm)
  Vias_Pad6.mirror(point=(0mm, 0mm, 0mm), normal=(0mm, 1mm, 0mm))
  Vias_Pad6.move(-(Resistor_CtoC/2)- (W_50/2)*sin(split_angle) -L_Split*cos(split_angle), 0mm, 0mm)
  [Pad5, Pad6, Vias_Pad5, Vias_Pad6].mirror(point=(-board_X/4, -2mm, 0mm), normal=(1mm, 0mm, 0mm))
  Pad7 = rectangle(corner=(-(board_X/4)-(SMA_Pad_Separation/2)-(SMA_Pad_W/2), -board_Y/2, board_Z), x_size=SMA_Pad_W, y_size=SMA_Pad_H)
  Pad7.thicken(copper_thickness)
  Pad8 = Pad7.duplicate_mirror(point=(-board_X/4, -18mm, 1.635mm), normal=(-1mm, 0mm, 0mm))
  Vias_Pad7 = cylinder(axis=Z, base_centre=(-(board_X/4)-(SMA_Pad_Separation/2), -board_Y/2+Via_edge_spacing, 0), radius=Via_Radius, height=board_Z)
  Vias_Pad7.duplicate_along_line(step=(0mm, Via_center_spacing, 0mm), total=Via_quantity, attached)
  Vias_Pad8 = Vias_Pad7.duplicate_mirror(point=(-board_X/4, -18mm, 1.635mm), normal=(1mm, 0mm, 0mm))
  [Pad7, Pad8, Vias_Pad7, Vias_Pad8].mirror(point=(0mm, 0mm, 0mm), normal=(1mm, 0mm, 0mm))
  Pad9 = rectangle(corner=(-(board_X/4)-(SMA_Pad_Separation/2)-(SMA_Pad_W/2), -board_Y/2, board_Z), x_size=SMA_Pad_W, y_size=SMA_Pad_H)
  Pad9.thicken(copper_thickness)
  Pad10 = Pad9.duplicate_mirror(point=(-board_X/4, -18mm, 1.635mm), normal=(-1mm, 0mm, 0mm))
  [Pad9, Pad10].mirror(point=(0mm, 0mm, 0mm), normal=(1mm, 0mm, 0mm))
  Vias_Pad9 = cylinder(axis=Z, base_centre=(-(board_X/4)-(SMA_Pad_Separation/2), -board_Y/2+Via_edge_spacing, 0), radius=Via_Radius, height=board_Z)
  Vias_Pad9.duplicate_along_line(step=(0mm, Via_center_spacing, 0mm), total=Via_quantity, attached)
  Vias_Pad10 = Vias_Pad9.duplicate_mirror(point=(-board_X/4, -18mm, 1.635mm), normal=(1mm, 0mm, 0mm))
  [Vias_Pad9, Vias_Pad10].mirror(point=(0mm, 0mm, 0mm), normal=(1mm, 0mm, 0mm))
  [Pad9, Pad10, Vias_Pad9, Vias_Pad10].mirror(point=(0mm, 0mm, 0mm), normal=(0mm, 1mm, 0mm))
  [Pad9, Pad10, Vias_Pad9, Vias_Pad10].move(-(Resistor_CtoC/2)- (W_50_2067/2)*sin(split_angle_2067) -L_split_2067*cos(split_angle_2067), 0mm, 0mm)
  Pad11 = rectangle(corner=(-(board_X/4)-(SMA_Pad_Separation/2)-(SMA_Pad_W/2), -board_Y/2, board_Z), x_size=SMA_Pad_W, y_size=SMA_Pad_H)
  Pad11.thicken(copper_thickness)
  Pad12 = Pad11.duplicate_mirror(point=(-board_X/4, -18mm, 1.635mm), normal=(-1mm, 0mm, 0mm))
  Pad11.mirror(point=(0mm, 0mm, 0mm), normal=(1mm, 0mm, 0mm))
  Pad11.mirror(point=(0mm, 0mm, 0mm), normal=(0mm, 1mm, 0mm))
  Pad11.move(-(Resistor_CtoC/2)- (W_50_2067/2)*sin(split_angle_2067) -L_split_2067*cos(split_angle_2067), 0mm, 0mm)
  Pad12.mirror(point=(0mm, 0mm, 0mm), normal=(1mm, 0mm, 0mm))
  Pad12.mirror(point=(0mm, 0mm, 0mm), normal=(0mm, 1mm, 0mm))
  Pad12.move(-(Resistor_CtoC/2)- (W_50_2067/2)*sin(split_angle_2067) -L_split_2067*cos(split_angle_2067), 0mm, 0mm)
  Vias_Pad11 = cylinder(axis=Z, base_centre=(-(board_X/4)-(SMA_Pad_Separation/2), -board_Y/2+Via_edge_spacing, 0), radius=Via_Radius, height=board_Z)
  Vias_Pad11.duplicate_along_line(step=(0mm, Via_center_spacing, 0mm), total=Via_quantity, attached)
  Vias_Pad12 = Vias_Pad11.duplicate_mirror(point=(-board_X/4, -18mm, 1.635mm), normal=(1mm, 0mm, 0mm))
  Vias_Pad11.mirror(point=(0mm, 0mm, 0mm), normal=(1mm, 0mm, 0mm))
  Vias_Pad11.mirror(point=(0mm, 0mm, 0mm), normal=(0mm, 1mm, 0mm))
  Vias_Pad11.move(-(Resistor_CtoC/2)- (W_50_2067/2)*sin(split_angle_2067) -L_split_2067*cos(split_angle_2067), 0mm, 0mm)
  Vias_Pad12.mirror(point=(0mm, 0mm, 0mm), normal=(1mm, 0mm, 0mm))
  Vias_Pad12.mirror(point=(0mm, 0mm, 0mm), normal=(0mm, 1mm, 0mm))
  Vias_Pad12.move(-(Resistor_CtoC/2)- (W_50_2067/2)*sin(split_angle_2067) -L_split_2067*cos(split_angle_2067), 0mm, 0mm)
  [Pad11, Pad12, Vias_Pad11, Vias_Pad12].mirror(point=(board_X/4, -2mm, 0mm), normal=(1mm, 0mm, 0mm))
  Ground.unite(Vias_Pad12, Vias_Pad11, Vias_Pad10, Vias_Pad9, Vias_Pad8, Vias_Pad7, Vias_Pad6, Vias_Pad5, Vias_Pad4, Vias_Pad3, Vias_Pad2, Vias_Pad1, Pad12, Pad11, Pad10, Pad9, Pad8, Pad7, Pad6, Pad5, Pad4, Pad3, Pad2, Pad1)
  732511159 = imported_body(C:\Users\Joshua Wong\Downloads\732511153.x_t)
  732511159.rotate(axis=X, angle=90deg)
  732511159.move(-board_X/4, -board_Y/2-9.525mm, board_Z+copper_thickness+0.3805mm)
  SMA_Dielectric6 [Teflon (tm)] = object_from(?.face(at (-17.5, -18.762, 2.0155)))
  SMA_Dielectric6.sweep_along_vector((0mm, -6.778mm, 0mm))
  732511153_ObjectFromFace1_7 = SMA_Dielectric6.copy()
  SMA_Dielectric_ObjectFromFace2 [Teflon (tm)] = object_from(SMA_Dielectric6.face(at (-17.5, -25.54, 2.0155)))
  732511159.subtract(732511153_ObjectFromFace1_7)
  732511159.separate_bodies()
  Cylinder2 = cylinder(axis=Y, base_centre=(-board_X/4, -board_Y/2-4.14mm, 2.0155mm), radius=0.6477mm, height=-3.4mm)
  732511159.subtract(Cylinder2)
  SMA_Probe1 [copper] = object_from(SMA_Probe1.face(at (-17.5, -22.14, 2.0155)))
  SMA_Probe1.sweep_along_vector((0mm, -3.4mm, 0mm))
  SMA_Probe1.unite(732511159)
  Solder_joint_SMA1 = rectangle(corner=((-board_X/4)-W_50/2, -board_Y/2, board_Z+copper_thickness), x_size=W_50, y_size=Solderblob_H)
  Rectangle7 = rectangle(corner=((-board_X/4)-Center_probe_rad, -board_Y/2, board_Z+copper_thickness+Center_probe_rad), x_size=Center_probe_rad*2, y_size=Center_probe_length)
  Solder_joint_SMA1.connect(Rectangle7)
  SMA_Probe1.unite(Solder_joint_SMA1)
  SMA_Probe_ObjectFromFace2 = object_from(SMA_Probe1.face(at (-24.4672, 25.54, 2.0155)))
  Input_Soldermask1 [SolderMask] = rectangle(corner=((-board_X/4)-W_50/2, -board_Y/2+Solderblob_H +Soldermask_clearance, board_Z+copper_thickness), x_size=W_50, y_size=Soldermask_dam_W)
  Input_Soldermask1.thicken(Solermask_thickness)
  SMA_Dielectric_ObjectFromFace2.unite(SMA_Probe_ObjectFromFace2)
  pecCap2 [pec] = sweep_along_normal(SMA_Dielectric_ObjectFromFace2.face(at (-24.4672, 25.54, 2.0155)), length=0.55mm)
  [SMA_Dielectric6, SMA_Probe1, Input_Soldermask1, SMA_Dielectric_ObjectFromFace2, pecCap2].mirror(point=(0mm, 0mm, 0mm), normal=(0mm, 1mm, 0mm))
  [SMA_Dielectric6, SMA_Probe1, Input_Soldermask1, SMA_Dielectric_ObjectFromFace2, pecCap2].move(-(Resistor_CtoC/2)- (W_50/2)*sin(split_angle) -L_Split*cos(split_angle), 0mm, 0mm)
  732511160 = imported_body(C:\Users\Joshua Wong\Downloads\732511153.x_t)
  732511160.rotate(axis=X, angle=90deg)
  732511160.move(-board_X/4, -board_Y/2-9.525mm, board_Z+copper_thickness+0.3805mm)
  SMA_Dielectric7 [Teflon (tm)] = object_from(?.face(at (-17.5, -18.762, 2.0155)))
  SMA_Dielectric7.sweep_along_vector((0mm, -6.778mm, 0mm))
  732511153_ObjectFromFace1_8 = SMA_Dielectric7.copy()
  SMA_Dielectric_ObjectFromFace3 [Teflon (tm)] = object_from(SMA_Dielectric7.face(at (-17.5, -25.54, 2.0155)))
  SMA_Dielectric7.mirror(point=(0mm, 0mm, 0mm), normal=(0mm, 1mm, 0mm))
  SMA_Dielectric7.move(-(Resistor_CtoC/2)- (W_50/2)*sin(split_angle) -L_Split*cos(split_angle), 0mm, 0mm)
  732511160.subtract(732511153_ObjectFromFace1_8)
  732511160.separate_bodies()
  Cylinder3 = cylinder(axis=Y, base_centre=(-board_X/4, -board_Y/2-4.14mm, 2.0155mm), radius=0.6477mm, height=-3.4mm)
  732511160.subtract(Cylinder3)
  SMA_Probe2 [copper] = object_from(SMA_Probe2.face(at (-17.5, -22.14, 2.0155)))
  SMA_Probe2.sweep_along_vector((0mm, -3.4mm, 0mm))
  SMA_Probe2.unite(732511160)
  Solder_joint_SMA2 = rectangle(corner=((-board_X/4)-W_50/2, -board_Y/2, board_Z+copper_thickness), x_size=W_50, y_size=Solderblob_H)
  Rectangle8 = rectangle(corner=((-board_X/4)-Center_probe_rad, -board_Y/2, board_Z+copper_thickness+Center_probe_rad), x_size=Center_probe_rad*2, y_size=Center_probe_length)
  Solder_joint_SMA2.connect(Rectangle8)
  SMA_Probe2.unite(Solder_joint_SMA2)
  SMA_Probe_ObjectFromFace3 = object_from(SMA_Probe2.face(at (-10.5328, 25.54, 2.0155)))
  SMA_Probe2.mirror(point=(0mm, 0mm, 0mm), normal=(0mm, 1mm, 0mm))
  SMA_Probe2.move(-(Resistor_CtoC/2)- (W_50/2)*sin(split_angle) -L_Split*cos(split_angle), 0mm, 0mm)
  Input_Soldermask2 [SolderMask] = rectangle(corner=((-board_X/4)-W_50/2, -board_Y/2+Solderblob_H +Soldermask_clearance, board_Z+copper_thickness), x_size=W_50, y_size=Soldermask_dam_W)
  Input_Soldermask2.thicken(Solermask_thickness)
  Input_Soldermask2.mirror(point=(0mm, 0mm, 0mm), normal=(0mm, 1mm, 0mm))
  Input_Soldermask2.move(-(Resistor_CtoC/2)- (W_50/2)*sin(split_angle) -L_Split*cos(split_angle), 0mm, 0mm)
  SMA_Dielectric_ObjectFromFace3.unite(SMA_Probe_ObjectFromFace3)
  pecCap3 [pec] = sweep_along_normal(SMA_Dielectric_ObjectFromFace3.face(at (-10.5328, 25.54, 2.0155)), length=0.55mm)
  SMA_Dielectric_ObjectFromFace3.mirror(point=(0mm, 0mm, 0mm), normal=(0mm, 1mm, 0mm))
  SMA_Dielectric_ObjectFromFace3.move(-(Resistor_CtoC/2)- (W_50/2)*sin(split_angle) -L_Split*cos(split_angle), 0mm, 0mm)
  pecCap3.mirror(point=(0mm, 0mm, 0mm), normal=(0mm, 1mm, 0mm))
  pecCap3.move(-(Resistor_CtoC/2)- (W_50/2)*sin(split_angle) -L_Split*cos(split_angle), 0mm, 0mm)
  [SMA_Dielectric7, SMA_Probe2, Input_Soldermask2, SMA_Dielectric_ObjectFromFace3, pecCap3].mirror(point=(-board_X/4, -2mm, 0mm), normal=(1mm, 0mm, 0mm))
  732511161 = imported_body(C:\Users\Joshua Wong\Downloads\732511153.x_t)
  732511161.rotate(axis=X, angle=90deg)
  732511161.move(-board_X/4, -board_Y/2-9.525mm, board_Z+copper_thickness+0.3805mm)
  SMA_Dielectric8 [Teflon (tm)] = object_from(?.face(at (-17.5, -18.762, 2.0155)))
  SMA_Dielectric8.sweep_along_vector((0mm, -6.778mm, 0mm))
  732511153_ObjectFromFace1_9 = SMA_Dielectric8.copy()
  SMA_Dielectric_ObjectFromFace4 [Teflon (tm)] = object_from(SMA_Dielectric8.face(at (-17.5, -25.54, 2.0155)))
  732511161.subtract(732511153_ObjectFromFace1_9)
  732511161.separate_bodies()
  Cylinder4 = cylinder(axis=Y, base_centre=(-board_X/4, -board_Y/2-4.14mm, 2.0155mm), radius=0.6477mm, height=-3.4mm)
  732511161.subtract(Cylinder4)
  SMA_Probe3 [copper] = object_from(SMA_Probe3.face(at (-17.5, -22.14, 2.0155)))
  SMA_Probe3.sweep_along_vector((0mm, -3.4mm, 0mm))
  SMA_Probe3.unite(732511161)
  Solder_joint_SMA3 = rectangle(corner=((-board_X/4)-W_50/2, -board_Y/2, board_Z+copper_thickness), x_size=W_50, y_size=Solderblob_H)
  Rectangle9 = rectangle(corner=((-board_X/4)-Center_probe_rad, -board_Y/2, board_Z+copper_thickness+Center_probe_rad), x_size=Center_probe_rad*2, y_size=Center_probe_length)
  Solder_joint_SMA3.connect(Rectangle9)
  SMA_Probe3.unite(Solder_joint_SMA3)
  SMA_Probe_ObjectFromFace4 = object_from(SMA_Probe3.face(at (17.5, -25.54, 2.0155)))
  Input_Soldermask3 [SolderMask] = rectangle(corner=((-board_X/4)-W_50/2, -board_Y/2+Solderblob_H +Soldermask_clearance, board_Z+copper_thickness), x_size=W_50, y_size=Soldermask_dam_W)
  Input_Soldermask3.thicken(Solermask_thickness)
  SMA_Dielectric_ObjectFromFace4.unite(SMA_Probe_ObjectFromFace4)
  pecCap4 [pec] = sweep_along_normal(SMA_Dielectric_ObjectFromFace4.face(at (17.5, -25.54, 2.0155)), length=0.55mm)
  [SMA_Dielectric8, SMA_Probe3, Input_Soldermask3, SMA_Dielectric_ObjectFromFace4, pecCap4].mirror(point=(0mm, 0mm, 0mm), normal=(1mm, 0mm, 0mm))
  732511162 = imported_body(C:\Users\Joshua Wong\Downloads\732511153.x_t)
  732511162.rotate(axis=X, angle=90deg)
  732511162.move(-board_X/4, -board_Y/2-9.525mm, board_Z+copper_thickness+0.3805mm)
  SMA_Dielectric9 [Teflon (tm)] = object_from(?.face(at (-17.5, -18.762, 2.0155)))
  SMA_Dielectric9.sweep_along_vector((0mm, -6.778mm, 0mm))
  732511153_ObjectFromFace1_10 = SMA_Dielectric9.copy()
  SMA_Dielectric_ObjectFromFace5 [Teflon (tm)] = object_from(SMA_Dielectric9.face(at (-17.5, -25.54, 2.0155)))
  SMA_Dielectric9.mirror(point=(0mm, 0mm, 0mm), normal=(1mm, 0mm, 0mm))
  732511162.subtract(732511153_ObjectFromFace1_10)
  732511162.separate_bodies()
  Cylinder5 = cylinder(axis=Y, base_centre=(-board_X/4, -board_Y/2-4.14mm, 2.0155mm), radius=0.6477mm, height=-3.4mm)
  732511162.subtract(Cylinder5)
  SMA_Probe4 [copper] = object_from(SMA_Probe4.face(at (-17.5, -22.14, 2.0155)))
  SMA_Probe4.sweep_along_vector((0mm, -3.4mm, 0mm))
  SMA_Probe4.unite(732511162)
  Solder_joint_SMA4 = rectangle(corner=((-board_X/4)-W_50/2, -board_Y/2, board_Z+copper_thickness), x_size=W_50, y_size=Solderblob_H)
  Rectangle10 = rectangle(corner=((-board_X/4)-Center_probe_rad, -board_Y/2, board_Z+copper_thickness+Center_probe_rad), x_size=Center_probe_rad*2, y_size=Center_probe_length)
  Solder_joint_SMA4.connect(Rectangle10)
  SMA_Probe4.unite(Solder_joint_SMA4)
  SMA_Probe_ObjectFromFace5 = object_from(SMA_Probe4.face(at (10.5328, 25.54, 2.0155)))
  SMA_Probe4.mirror(point=(0mm, 0mm, 0mm), normal=(1mm, 0mm, 0mm))
  Input_Soldermask4 [SolderMask] = rectangle(corner=((-board_X/4)-W_50/2, -board_Y/2+Solderblob_H +Soldermask_clearance, board_Z+copper_thickness), x_size=W_50, y_size=Soldermask_dam_W)
  Input_Soldermask4.thicken(Solermask_thickness)
  Input_Soldermask4.mirror(point=(0mm, 0mm, 0mm), normal=(1mm, 0mm, 0mm))
  SMA_Dielectric_ObjectFromFace5.unite(SMA_Probe_ObjectFromFace5)
  pecCap5 [pec] = sweep_along_normal(SMA_Dielectric_ObjectFromFace5.face(at (10.5328, 25.54, 2.0155)), length=0.55mm)
  [SMA_Dielectric_ObjectFromFace5, pecCap5].mirror(point=(0mm, 0mm, 0mm), normal=(1mm, 0mm, 0mm))
  [SMA_Dielectric9, SMA_Probe4, Input_Soldermask4, SMA_Dielectric_ObjectFromFace5, pecCap5].mirror(point=(0mm, 0mm, 0mm), normal=(0mm, 1mm, 0mm))
  [SMA_Dielectric9, SMA_Probe4, Input_Soldermask4, SMA_Dielectric_ObjectFromFace5, pecCap5].move(-(Resistor_CtoC/2)- (W_50_2067/2)*sin(split_angle_2067) -L_split_2067*cos(split_angle_2067), 0mm, 0mm)
  732511163 = imported_body(C:\Users\Joshua Wong\Downloads\732511153.x_t)
  732511163.rotate(axis=X, angle=90deg)
  732511163.move(-board_X/4, -board_Y/2-9.525mm, board_Z+copper_thickness+0.3805mm)
  SMA_Dielectric10 [Teflon (tm)] = object_from(?.face(at (-17.5, -18.762, 2.0155)))
  SMA_Dielectric10.sweep_along_vector((0mm, -6.778mm, 0mm))
  732511153_ObjectFromFace1_11 = SMA_Dielectric10.copy()
  SMA_Dielectric_ObjectFromFace6 [Teflon (tm)] = object_from(SMA_Dielectric10.face(at (-17.5, -25.54, 2.0155)))
  SMA_Dielectric10.mirror(point=(0mm, 0mm, 0mm), normal=(1mm, 0mm, 0mm))
  SMA_Dielectric10.mirror(point=(0mm, 0mm, 0mm), normal=(0mm, 1mm, 0mm))
  SMA_Dielectric10.move(-(Resistor_CtoC/2)- (W_50_2067/2)*sin(split_angle_2067) -L_split_2067*cos(split_angle_2067), 0mm, 0mm)
  732511163.subtract(732511153_ObjectFromFace1_11)
  732511163.separate_bodies()
  Cylinder6 = cylinder(axis=Y, base_centre=(-board_X/4, -board_Y/2-4.14mm, 2.0155mm), radius=0.6477mm, height=-3.4mm)
  732511163.subtract(Cylinder6)
  SMA_Probe5 [copper] = object_from(SMA_Probe5.face(at (-17.5, -22.14, 2.0155)))
  SMA_Probe5.sweep_along_vector((0mm, -3.4mm, 0mm))
  SMA_Probe5.unite(732511163)
  Solder_joint_SMA5 = rectangle(corner=((-board_X/4)-W_50/2, -board_Y/2, board_Z+copper_thickness), x_size=W_50, y_size=Solderblob_H)
  Rectangle11 = rectangle(corner=((-board_X/4)-Center_probe_rad, -board_Y/2, board_Z+copper_thickness+Center_probe_rad), x_size=Center_probe_rad*2, y_size=Center_probe_length)
  Solder_joint_SMA5.connect(Rectangle11)
  SMA_Probe5.unite(Solder_joint_SMA5)
  SMA_Probe_ObjectFromFace6 = object_from(SMA_Probe5.face(at (24.4672, 25.54, 2.0155)))
  SMA_Probe5.mirror(point=(0mm, 0mm, 0mm), normal=(1mm, 0mm, 0mm))
  SMA_Probe5.mirror(point=(0mm, 0mm, 0mm), normal=(0mm, 1mm, 0mm))
  SMA_Probe5.move(-(Resistor_CtoC/2)- (W_50_2067/2)*sin(split_angle_2067) -L_split_2067*cos(split_angle_2067), 0mm, 0mm)
  Input_Soldermask5 [SolderMask] = rectangle(corner=((-board_X/4)-W_50/2, -board_Y/2+Solderblob_H +Soldermask_clearance, board_Z+copper_thickness), x_size=W_50, y_size=Soldermask_dam_W)
  Input_Soldermask5.thicken(Solermask_thickness)
  Input_Soldermask5.mirror(point=(0mm, 0mm, 0mm), normal=(1mm, 0mm, 0mm))
  Input_Soldermask5.mirror(point=(0mm, 0mm, 0mm), normal=(0mm, 1mm, 0mm))
  Input_Soldermask5.move(-(Resistor_CtoC/2)- (W_50_2067/2)*sin(split_angle_2067) -L_split_2067*cos(split_angle_2067), 0mm, 0mm)
  SMA_Dielectric_ObjectFromFace6.unite(SMA_Probe_ObjectFromFace6)
  pecCap6 [pec] = sweep_along_normal(SMA_Dielectric_ObjectFromFace6.face(at (24.4672, 25.54, 2.0155)), length=0.55mm)
  SMA_Dielectric_ObjectFromFace6.mirror(point=(0mm, 0mm, 0mm), normal=(1mm, 0mm, 0mm))
  SMA_Dielectric_ObjectFromFace6.mirror(point=(0mm, 0mm, 0mm), normal=(0mm, 1mm, 0mm))
  SMA_Dielectric_ObjectFromFace6.move(-(Resistor_CtoC/2)- (W_50_2067/2)*sin(split_angle_2067) -L_split_2067*cos(split_angle_2067), 0mm, 0mm)
  pecCap6.mirror(point=(0mm, 0mm, 0mm), normal=(1mm, 0mm, 0mm))
  pecCap6.mirror(point=(0mm, 0mm, 0mm), normal=(0mm, 1mm, 0mm))
  pecCap6.move(-(Resistor_CtoC/2)- (W_50_2067/2)*sin(split_angle_2067) -L_split_2067*cos(split_angle_2067), 0mm, 0mm)
  [SMA_Dielectric10, SMA_Probe5, Input_Soldermask5, SMA_Dielectric_ObjectFromFace6, pecCap6].mirror(point=(board_X/4, -2mm, 0mm), normal=(1mm, 0mm, 0mm))
  Copper_trace_2245.fillet(Vertices=Copper_trace_2245.vertex(at (-23.0072, 9.41663, 1.6)) Radius=fillet_radius Setback=0mm)
  Copper_trace_2245.fillet(Vertices=Copper_trace_2245.vertex(at (-25.9272, 7.73077, 1.6)) Radius=fillet_radius Setback=0mm)
  Copper_trace_2245.fillet(Vertices=Copper_trace_2245.vertex(at (-11.9928, 9.41663, 1.6)) Radius=fillet_radius Setback=0mm)
  Copper_trace_2245.fillet(Vertices=Copper_trace_2245.vertex(at (-9.07282, 7.73077, 1.6)) Radius=fillet_radius Setback=0mm)
  Copper_trace_2245.fillet(Vertices=Copper_trace_2245.vertex(at (-17.675, 6.3381, 1.6)) Radius=fillet_radius_small Setback=0mm)
  Copper_trace_2245.fillet(Vertices=Copper_trace_2245.vertex(at (-21.7347, 5.31027, 1.6)) Radius=fillet_radius_small Setback=0mm)
  Copper_trace_2245.fillet(Vertices=Copper_trace_2245.vertex(at (-13.2653, 5.31027, 1.6)) Radius=fillet_radius_small Setback=0mm)
  Copper_trace_2245.fillet(Vertices=Copper_trace_2245.vertex(at (-17.325, 6.3381, 1.6)) Radius=fillet_radius_small Setback=0mm)
  Copper_trace_2245.thicken(copper_thickness)
  Copper_trace_2067.fillet(Vertices=Copper_trace_2067.vertex(at (13.2162, 6.16622, 1.6)) Radius=fillet_radius_small Setback=0mm)
  Copper_trace_2067.fillet(Vertices=Copper_trace_2067.vertex(at (21.7838, 6.16622, 1.6)) Radius=fillet_radius_small Setback=0mm)
  Copper_trace_2067.fillet(Vertices=Copper_trace_2067.vertex(at (17.325, 7.16571, 1.6)) Radius=fillet_radius_small Setback=0mm)
  Copper_trace_2067.fillet(Vertices=Copper_trace_2067.vertex(at (17.675, 7.16571, 1.6)) Radius=fillet_radius_small Setback=0mm)
  Copper_trace_2067.fillet(Vertices=Copper_trace_2067.vertex(at (11.9928, 10.2442, 1.6)) Radius=fillet_radius Setback=0mm)
  Copper_trace_2067.fillet(Vertices=Copper_trace_2067.vertex(at (9.07282, 8.55838, 1.6)) Radius=fillet_radius Setback=0mm)
  Copper_trace_2067.fillet(Vertices=Copper_trace_2067.vertex(at (23.0072, 10.2442, 1.6)) Radius=fillet_radius Setback=0mm)
  Copper_trace_2067.fillet(Vertices=Copper_trace_2067.vertex(at (25.9272, 8.55838, 1.6)) Radius=fillet_radius Setback=0mm)
  Copper_trace_2067.thicken(copper_thickness)
  group SMA_Port1 = SMA_Dielectric, SMA_Probe, Input_Soldermask, SMA_Dielectric_ObjectFromFace1, pecCap1
  group SMA_Port2 = SMA_Dielectric6, SMA_Probe1, Input_Soldermask1, SMA_Dielectric_ObjectFromFace2, pecCap2
  group SMA_Port3 = SMA_Dielectric7, SMA_Probe2, Input_Soldermask2, SMA_Dielectric_ObjectFromFace3, pecCap3
  group SMA_Port4 = SMA_Dielectric8, SMA_Probe3, Input_Soldermask3, SMA_Dielectric_ObjectFromFace4, pecCap4
  group SMA_Port5 = SMA_Dielectric9, SMA_Probe4, Input_Soldermask4, SMA_Dielectric_ObjectFromFace5, pecCap5
  group SMA_Port6 = SMA_Dielectric10, SMA_Probe5, Input_Soldermask5, SMA_Dielectric_ObjectFromFace6, pecCap6
boundaries and excitations:
  Ground: Perfect E Objects=Ground
  LumpRLC1: Lumped RLC Objects=Resistor_100ohms CurrentLine{(-17.675, 5.5005999, 1.6) -> (-17.325, 5.5005999, 1.6)} RLC_Type=Serial Resistance=100ohm
  Open1: Radiation Objects=RadiatingSurface
  LumpRLC2: Lumped RLC Objects=Resistor_100ohms_2067 CurrentLine{(17.325, 6.3282056, 1.6) -> (17.675, 6.3282056, 1.6)} RLC_Type=Serial Resistance=100ohm
  Port1: Terminal port=1 Faces=SMA_Probe.face(at (-17.5, -25.54, 2.0155)) TerminalResistance=50ohm
  Port2: Terminal port=2 Faces=SMA_Probe1.face(at (-24.4672, 25.54, 2.0155)) TerminalResistance=50ohm
  Port3: Terminal port=3 Faces=SMA_Probe2.face(at (-10.5328, 25.54, 2.0155)) TerminalResistance=50ohm
  Port4: Terminal port=4 Faces=SMA_Probe3.face(at (17.5, -25.54, 2.0155)) TerminalResistance=50ohm
  Port5: Terminal port=5 Faces=SMA_Probe4.face(at (10.5328, 25.54, 2.0155)) TerminalResistance=50ohm
  Port6: Terminal port=6 Faces=SMA_Probe5.face(at (24.4672, 25.54, 2.0155)) TerminalResistance=50ohm
  1: Wave Port Faces=SMA_Dielectric_ObjectFromFace1.face(at (-17.5, -25.54, 2.0155)) WavePortType=Terminal NumModes=1
  2: Wave Port Faces=SMA_Dielectric_ObjectFromFace2.face(at (-24.4672, 25.54, 2.0155)) WavePortType=Terminal NumModes=1
  3: Wave Port Faces=SMA_Dielectric_ObjectFromFace3.face(at (-10.5328, 25.54, 2.0155)) WavePortType=Terminal NumModes=1
  4: Wave Port Faces=SMA_Dielectric_ObjectFromFace4.face(at (17.5, -25.54, 2.0155)) WavePortType=Terminal NumModes=1
  5: Wave Port Faces=SMA_Dielectric_ObjectFromFace5.face(at (10.5328, 25.54, 2.0155)) WavePortType=Terminal NumModes=1
  6: Wave Port Faces=SMA_Dielectric_ObjectFromFace6.face(at (24.4672, 25.54, 2.0155)) WavePortType=Terminal NumModes=1
  reference conductors: Ground
setups:
  both_frequencies: HfssDriven Frequency=5GHz MaxDeltaS=0.02 MaximumPasses=20 MinimumPasses=1 MinimumConvergedPasses=1 PercentRefinement=30 BasisOrder=1 PortAccuracy=2 DrivenSolverType="Direct Solver"
    sweep Sweep: 1GHz to 3.5GHz step 10MHz; Type=Interpolating InterpTolerance=0.5 InterpMaxSolns=250 PassivityErrorTolerance=0.0001
source amplitudes:
  1:1, 2:1, 3:1, 4:1, 5:1, 6:1: 1V 0deg
optimetrics:
  2067_arc: Parametric Sim._Setups=[both_frequencies]
    sweep quarterwave_2067: LIN 25.4mm 27.4mm 0.2mm
  2245_arc: Parametric Sim._Setups=[both_frequencies]
    sweep quarterwave_2245: LIN 24.1mm 25.1mm 0.2mm
radiation setups:
  3D: Infinite Sphere Theta=0deg..180deg step 2deg Phi=-180deg..180deg step 2deg
  Elevation: Infinite Sphere Theta=-180deg..180deg step 1deg Phi=0deg..90deg step 90deg
  Azimuth: Infinite Sphere Theta=90deg..90deg step 0deg Phi=-180deg..180deg step 1deg
reports:
  Terminal S Parameter Plot1: dB(St(Port1,Port1)), dB(St(Port2,Port1)), dB(St(Port3,Port1)), dB(St(Port1,Port2)), dB(St(Port2,Port2)), dB(St(Port3,Port2)), dB(St(Port1,Port3)), dB(St(Port2,Port3)), dB(St(Port3,Port3)) vs Freq on both_frequencies : Sweep [quarterwave_2245=24.7mm quarterwave_2067=26mm]; markers MX1 at x=2.2447479e+09
  Terminal S Parameter Plot2: dB(St(Port4,Port4)), dB(St(Port5,Port4)), dB(St(Port6,Port4)), dB(St(Port4,Port5)), dB(St(Port5,Port5)), dB(St(Port6,Port5)), dB(St(Port4,Port6)), dB(St(Port5,Port6)), dB(St(Port6,Port6)) vs Freq on both_frequencies : Sweep [quarterwave_2245=24.7mm quarterwave_2067=26mm]; markers MX1 at x=2.0666488e+09
  Terminal S Parameter Plot3: dB(St(Port3,Port3)) vs Freq on both_frequencies : Sweep [quarterwave_2245=all]; markers MX1 at x=2.2447479e+09

design Wilkinson_V7 (HFSS, HFSS Terminal Network, model units mm)
options: Allow_Material_Override
variables:
  board_X = 70mm
  board_Y = 38mm
  board_Z = 1.6mm
  W_50 = 2.92mm  # 50 Ohm trace width
  L_Port1_Trace = 8mm  # Port 1 trace length
  W_70p7 = 1.45mm  # 70.7 Ohm trace width
  Resistor_CtoC = 0.35mm  # 0603 footprint copper to copper distance
  quarterwave_2245 = 26.4mm
  Radius = (quarterwave_2245-(Resistor_CtoC/2))/pi
  turn_radius = 5mm
  L_Split = 7mm
  offset = 3.5mm
  split_angle = 30deg  # Angle from X-axis to diagonal trace
  fillet_radius = 1.5mm
  W_50_2067 = 2.92mm
  L_Port1_Trace_2067 = 8mm
  W_70p7_2067 = 1.45mm
  quarterwave_2067 = 28.3mm
  Radius_2067 = (quarterwave_2067-(Resistor_CtoC/2))/pi
  L_split_2067 = 7mm
  offset_2067 = 3.5mm
  split_angle_2067 = 30deg
  copper_thickness = 0.035mm
  er_FR4 = 4.5
  SMA_Pad_W = 2.415mm
  SMA_Pad_H = 5.84mm
  SMA_Pad_Separation = 8.765mm
  Resistor_Height = 0.5mm
  Via_Radius = 0.15mm
  Via_edge_spacing = 1.2mm
  Via_center_spacing = 1.2mm
  Via_quantity = 3
  Resistor_pad_W = 0.45mm
  Resistor_pad_H = 0.6mm
  Solderblob_H = 5.4mm
  Center_probe_rad = 0.38mm
  Center_probe_length = 4.75mm
  Soldermask_clearance = 0.075mm
  Soldermask_dam_W = 0.2mm
  Solermask_thickness = 0.02mm
  Port_Rad = 2.1081331mm
  L_parallel = 1mm
  fillet_radius_small = 0.2mm
geometry:
  Ground [copper] = rectangle(corner=(-board_X/2, -board_Y/2, 0mm), x_size=board_X, y_size=board_Y)
  Substrate [FR4_epoxy_Wilkinson] = box(corner=(-board_X/2, -board_Y/2, 0mm), size=(board_X, board_Y, board_Z))
  Copper_trace_2245 [copper] = rectangle(corner=(-(board_X/4)-(W_50/2), -board_Y/2, 1.6mm), x_size=W_50, y_size=L_Port1_Trace)
  Stub_1 = rectangle(corner=(-(board_X/4)-(Resistor_CtoC/2), -(board_Y/2)+L_Port1_Trace-(W_70p7/2), board_Z), x_size=Resistor_CtoC/2, y_size=W_70p7)
  Stub_2 = rectangle(corner=(-(board_X/4), -(board_Y/2)+L_Port1_Trace-(W_70p7/2), board_Z), x_size=Resistor_CtoC/2, y_size=W_70p7)
  Arc_1_Line = polyline((-(board_X/4)-(Resistor_CtoC/2), -(board_Y/2)+L_Port1_Trace, board_Z) (-26.022677mm, -2.6523232mm, 1.6mm) (-17.675mm, 5.6953535mm, 1.6mm), AngularArc from point 0 over 3 centre=(-(board_X/4)-(Resistor_CtoC/2), -(board_Y/2)+L_Port1_Trace+Radius, board_Z) angle=-180deg plane=XY)
  Arc_1_Line1 = polyline((-(board_X/4)+(Resistor_CtoC/2), -(board_Y/2)+L_Port1_Trace, board_Z) (-8.9773232mm, -2.6523232mm, 1.6mm) (-17.325mm, 5.6953535mm, 1.6mm), AngularArc from point 0 over 3 centre=(-(board_X/4)+(Resistor_CtoC/2), -(board_Y/2)+L_Port1_Trace+Radius, board_Z) angle=180deg plane=XY)
  Arc_1 = polyline((-(board_X/4)-(Resistor_CtoC/2), -(board_Y/2)+L_Port1_Trace-(W_70p7/2), board_Z) (-(board_X/4)-(Resistor_CtoC/2), -(board_Y/2)+L_Port1_Trace+(W_70p7/2), board_Z))
  Arc_1.sweep_along_path(Arc_1_Line)
  Arc_2 = polyline((-(board_X/4)+(Resistor_CtoC/2), -(board_Y/2)+L_Port1_Trace-(W_70p7/2), board_Z) (-(board_X/4)+(Resistor_CtoC/2), -(board_Y/2)+L_Port1_Trace+(W_70p7/2), board_Z))
  Arc_2.sweep_along_path(Arc_1_Line1)
  Resistor_100ohms = rectangle(corner=(-(board_X/4)-(Resistor_CtoC/2), -(board_Y/2)+L_Port1_Trace+2*Radius-(W_70p7 /2)+(W_70p7/4), board_Z), x_size=Resistor_CtoC, y_size=Resistor_Height)
  RadiatingSurface [vacuum] = region(absolute_offset=44.54343mm on all sides)
  Copper_trace_2067 [copper] = rectangle(corner=(-(board_X/4)-(W_50_2067/2), -board_Y/2, board_Z), x_size=W_50_2067, y_size=L_Port1_Trace_2067)
  Stub_3 = rectangle(corner=(-(board_X/4)-(Resistor_CtoC/2), -(board_Y/2)+L_Port1_Trace_2067-(W_70p7_2067/2), board_Z), x_size=Resistor_CtoC/2, y_size=W_70p7_2067)
  Stub_4 = rectangle(corner=(-(board_X/4), -(board_Y/2)+L_Port1_Trace_2067-(W_70p7_2067/2), board_Z), x_size=Resistor_CtoC/2, y_size=W_70p7_2067)
  Arc_1_Line2 = polyline((-(board_X/4)-(Resistor_CtoC/2), -(board_Y/2)+L_Port1_Trace_2067, board_Z) (-26.627466mm, -2.0475345mm, 1.6mm) (-17.675mm, 6.9049311mm, 1.6mm), AngularArc from point 0 over 3 centre=(-(board_X/4)-(Resistor_CtoC/2), -(board_Y/2)+L_Port1_Trace_2067+Radius_2067, board_Z) angle=-180deg plane=XY)
  Arc_1_Line3 = polyline((-(board_X/4)+(Resistor_CtoC/2), -(board_Y/2)+L_Port1_Trace_2067, board_Z) (-8.3725345mm, -2.0475345mm, 1.6mm) (-17.325mm, 6.9049311mm, 1.6mm), AngularArc from point 0 over 3 centre=(-(board_X/4)+(Resistor_CtoC/2), -(board_Y/2)+L_Port1_Trace_2067+Radius_2067, board_Z) angle=180deg plane=XY)
  Arc_3 = polyline((-(board_X/4)-(Resistor_CtoC/2), -(board_Y/2)+L_Port1_Trace_2067-(W_70p7_2067/2), board_Z) (-(board_X/4)-(Resistor_CtoC/2), -(board_Y/2)+L_Port1_Trace_2067+(W_70p7_2067/2), board_Z))
  Arc_3.sweep_along_path(Arc_1_Line2)
  Arc_4 = polyline((-(board_X/4)+(Resistor_CtoC/2), -(board_Y/2)+L_Port1_Trace_2067-(W_70p7_2067/2), board_Z) (-(board_X/4)+(Resistor_CtoC/2), -(board_Y/2)+L_Port1_Trace_2067+(W_70p7_2067/2), board_Z))
  Arc_4.sweep_along_path(Arc_1_Line3)
  Resistor_100ohms_2067 = rectangle(corner=((board_X/4)-(Resistor_CtoC/2), -(board_Y/2)+L_Port1_Trace_2067+2*Radius_2067-(W_70p7_2067/2)+(W_70p7_2067/4), board_Z), x_size=Resistor_CtoC, y_size=Resistor_Height)
  Ground.thicken(-copper_thickness)
  Resistor_pad_outline_2245 = rectangle(corner=(-(board_X/4)-(Resistor_CtoC/2)-Resistor_pad_W, -(board_Y/2)+L_Port1_Trace+2*Radius-(W_70p7 /2)+(W_70p7/4)-(Resistor_pad_H-Resistor_Height)/2, board_Z+copper_thickness), x_size=Resistor_pad_W, y_size=Resistor_pad_H)
  Rectangle1_1 = Resistor_pad_outline_2245.duplicate_mirror(point=(-board_X/4, 6.8328535mm, 1.6mm), normal=(1mm, 0mm, 0mm))
  Resistor_pad_outline_2245.unite(Rectangle1_1)
  Resistor_pad_outline_2067 = rectangle(corner=((board_X/4)-(Resistor_CtoC/2) -Resistor_pad_W, -(board_Y/2)+L_Port1_Trace_2067+2*Radius_2067-(W_70p7_2067/2)+(W_70p7_2067/4)-(Resistor_pad_H-Resistor_Height)/2, board_Z+copper_thickness), x_size=Resistor_pad_W, y_size=Resistor_pad_H)
  Rectangle1_2 = Resistor_pad_outline_2067.duplicate_mirror(point=(board_X/4, 8.0424311mm, 1.6mm), normal=(1mm, 0mm, 0mm))
  Resistor_pad_outline_2067.unite(Rectangle1_2)
  Resistor_soldermask_2245 [SolderMask] = rectangle(corner=(-(board_X/4)-(Resistor_CtoC/2)-Resistor_pad_W-Soldermask_clearance-Soldermask_dam_W, -(board_Y/2)+L_Port1_Trace+2*Radius-(W_70p7 /2)+(W_70p7/4)-(Resistor_pad_H-Resistor_Height)/2-Soldermask_clearance-Soldermask_dam_W, board_Z+copper_thickness), x_size=Soldermask_clearance+Soldermask_dam_W+Resistor_pad_W, y_size=2*(Soldermask_clearance+Soldermask_dam_W)+Resistor_pad_H)
  Rectangle5 = rectangle(corner=(-(board_X/4)-(Resistor_CtoC/2)-Resistor_pad_W-Soldermask_clearance, -(board_Y/2)+L_Port1_Trace+2*Radius-(W_70p7 /2)+(W_70p7/4)-(Resistor_pad_H-Resistor_Height)/2-Soldermask_clearance, board_Z+copper_thickness), x_size=Soldermask_clearance+Resistor_pad_W, y_size=2*(Soldermask_clearance)+Resistor_pad_H)
  Resistor_soldermask_2245.subtract(Rectangle5)
  Resistor_soldermask_2245.thicken(Solermask_thickness)
  Rectangle4_1 = Resistor_soldermask_2245.duplicate_mirror(point=(-board_X/4, 6.8328535mm, 1.6mm), normal=(1mm, 0mm, 0mm))
  Resistor_soldermask_2245.unite(Rectangle4_1)
  Resistor_soldermask_2067 [SolderMask] = rectangle(corner=((board_X/4)-(Resistor_CtoC/2)-Resistor_pad_W-Soldermask_clearance-Soldermask_dam_W, -(board_Y/2)+L_Port1_Trace_2067+2*Radius_2067-(W_70p7_2067 /2)+(W_70p7_2067/4)-(Resistor_pad_H-Resistor_Height)/2-Soldermask_clearance-Soldermask_dam_W, board_Z+copper_thickness), x_size=Soldermask_clearance+Soldermask_dam_W+Resistor_pad_W, y_size=2*(Soldermask_clearance+Soldermask_dam_W)+Resistor_pad_H)
  Rectangle6 = rectangle(corner=((board_X/4)-(Resistor_CtoC/2)-Resistor_pad_W-Soldermask_clearance, -(board_Y/2)+L_Port1_Trace_2067+2*Radius_2067-(W_70p7_2067 /2)+(W_70p7_2067/4)-(Resistor_pad_H-Resistor_Height)/2-Soldermask_clearance, board_Z+copper_thickness), x_size=Soldermask_clearance+Resistor_pad_W, y_size=2*(Soldermask_clearance)+Resistor_pad_H)
  Resistor_soldermask_2067.subtract(Rectangle6)
  Resistor_soldermask_2067.thicken(Solermask_thickness)
  Resistor_soldermask_2246_1 = Resistor_soldermask_2067.duplicate_mirror(point=(board_X/4, 8.0424311mm, 1.6mm), normal=(1mm, 0mm, 0mm))
  Resistor_soldermask_2067.unite(Resistor_soldermask_2246_1)
  Polyline13 = polyline((-(board_X/4)-(Resistor_CtoC/2), -(board_Y/2)+L_Port1_Trace+2*Radius+W_70p7/2, board_Z) (-(board_X/4)-(Resistor_CtoC/2)-W_50*sin(split_angle), -(board_Y/2)+L_Port1_Trace+2*Radius+W_70p7/2- W_50*cos(split_angle), board_Z))
  Polyline14 = polyline((-(board_X/4)-(Resistor_CtoC/2)- (W_50/2)*sin(split_angle), -(board_Y/2)+L_Port1_Trace+2*Radius+W_70p7/2- (W_50/2)*cos(split_angle), board_Z) (-(board_X/4)-(Resistor_CtoC/2)- (W_50/2)*sin(split_angle) -L_Split*cos(split_angle), -(board_Y/2)+L_Port1_Trace+2*Radius+W_70p7/2- (W_50/2)*cos(split_angle)+L_Split*sin(split_angle), board_Z))
  Polyline15 = polyline((-(board_X/4)-(Resistor_CtoC/2)- (W_50/2)*sin(split_angle) -L_Split*cos(split_angle), -(board_Y/2)+L_Port1_Trace+2*Radius+W_70p7/2- (W_50/2)*cos(split_angle)+L_Split*sin(split_angle), board_Z) (-(board_X/4)-(Resistor_CtoC/2)- (W_50/2)*sin(split_angle) -L_Split*cos(split_angle), board_Y/2, board_Z))
  Circle1 = circle(normal=Z, centre=(-(board_X/4)-(Resistor_CtoC/2), -(board_Y/2)+L_Port1_Trace+Radius, board_Z), radius=Radius-W_70p7/2)
  Polyline14.unite(Polyline15)
  Polyline13.sweep_along_path(Polyline14)
  Polyline13.subtract(Circle1)
  Polyline13_1 = Polyline13.duplicate_mirror(point=(-board_X/4, 4.8328535mm, 1.6mm), normal=(1mm, 0mm, 0mm))
  Copper_trace_2245.unite(Polyline13_1, Polyline13, Arc_2, Arc_1, Stub_1, Stub_2)
  Polyline16 = polyline((-(board_X/4)-(Resistor_CtoC/2), -(board_Y/2)+L_Port1_Trace_2067+2*Radius_2067 +W_70p7_2067/2, board_Z) (-(board_X/4)-(Resistor_CtoC/2)-(W_50_2067)*sin(split_angle_2067), -(board_Y/2)+L_Port1_Trace_2067+2*Radius_2067 +W_70p7_2067/2-(W_50_2067)*cos(split_angle_2067), board_Z))
  Polyline17 = polyline((-(board_X/4)-(Resistor_CtoC/2)-(W_50_2067/2)*sin(split_angle_2067), -(board_Y/2)+L_Port1_Trace_2067+2*Radius_2067 +W_70p7_2067/2-(W_50_2067/2)*cos(split_angle_2067), board_Z) (-(board_X/4)-(Resistor_CtoC/2)-(W_50_2067/2)*sin(split_angle_2067)-L_split_2067*cos(split_angle_2067), -(board_Y/2)+L_Port1_Trace_2067+2*Radius_2067 +W_70p7_2067/2-(W_50_2067/2)*cos(split_angle_2067)+L_split_2067*sin(split_angle_2067), board_Z))
  Polyline18 = polyline((-(board_X/4)-(Resistor_CtoC/2)-(W_50_2067/2)*sin(split_angle_2067)-L_split_2067*cos(split_angle_2067), -(board_Y/2)+L_Port1_Trace_2067+2*Radius_2067 +W_70p7_2067/2-(W_50_2067/2)*cos(split_angle_2067)+L_split_2067*sin(split_angle_2067), board_Z) (-(board_X/4)-(Resistor_CtoC/2)-(W_50_2067/2)*sin(split_angle_2067)-L_split_2067*cos(split_angle_2067), (board_Y/2), board_Z))
  Polyline17.unite(Polyline18)
  Polyline16.sweep_along_path(Polyline17)
  Circle2 = circle(normal=Z, centre=(-(board_X/4)-(Resistor_CtoC/2), -(board_Y/2)+L_Port1_Trace_2067+Radius_2067, board_Z), radius=Radius_2067-W_70p7_2067/2)
  Polyline16.subtract(Circle2)
  Polyline16_1 = Polyline16.duplicate_mirror(point=(-board_X/4, 4.8328535mm, 1.6mm), normal=(1mm, 0mm, 0mm))
  Copper_trace_2067.unite(Stub_3, Stub_4, Polyline16, Polyline16_1, Arc_4, Arc_3)
  Copper_trace_2067.mirror(point=(0mm, 0mm, 0mm), normal=(1mm, 0mm, 0mm))
  Copper_trace_2245.fillet(Vertices=Copper_trace_2245.vertex(at (-23.0072, 9.49889, 1.6)) Radius=fillet_radius Setback=0mm)
  Copper_trace_2245.fillet(Vertices=Copper_trace_2245.vertex(at (-25.9272, 7.81303, 1.6)) Radius=fillet_radius Setback=0mm)
  Copper_trace_2245.fillet(Vertices=Copper_trace_2245.vertex(at (-11.9928, 9.49889, 1.6)) Radius=fillet_radius Setback=0mm)
  Copper_trace_2245.fillet(Vertices=Copper_trace_2245.vertex(at (-9.07282, 7.81303, 1.6)) Radius=fillet_radius Setback=0mm)
  Copper_trace_2245.fillet(Vertices=Copper_trace_2245.vertex(at (-17.675, 6.42035, 1.6)) Radius=fillet_radius_small Setback=0mm)
  Copper_trace_2245.fillet(Vertices=Copper_trace_2245.vertex(at (-21.7983, 5.42924, 1.6)) Radius=fillet_radius_small Setback=0mm)
  Copper_trace_2245.fillet(Vertices=Copper_trace_2245.vertex(at (-13.2017, 5.42924, 1.6)) Radius=fillet_radius_small Setback=0mm)
  Copper_trace_2245.fillet(Vertices=Copper_trace_2245.vertex(at (-17.325, 6.42035, 1.6)) Radius=fillet_radius_small Setback=0mm)
  Copper_trace_2245.thicken(copper_thickness)
  Copper_trace_2067.fillet(Vertices=Copper_trace_2067.vertex(at (13.1364, 6.6765, 1.6)) Radius=fillet_radius_small Setback=0mm)
  Copper_trace_2067.fillet(Vertices=Copper_trace_2067.vertex(at (21.8636, 6.6765, 1.6)) Radius=fillet_radius_small Setback=0mm)
  Copper_trace_2067.fillet(Vertices=Copper_trace_2067.vertex(at (17.325, 7.62993, 1.6)) Radius=fillet_radius_small Setback=0mm)
  Copper_trace_2067.fillet(Vertices=Copper_trace_2067.vertex(at (17.675, 7.62993, 1.6)) Radius=fillet_radius_small Setback=0mm)
  Copper_trace_2067.fillet(Vertices=Copper_trace_2067.vertex(at (11.9928, 10.7085, 1.6)) Radius=fillet_radius Setback=0mm)
  Copper_trace_2067.fillet(Vertices=Copper_trace_2067.vertex(at (9.07282, 9.0226, 1.6)) Radius=fillet_radius Setback=0mm)
  Copper_trace_2067.fillet(Vertices=Copper_trace_2067.vertex(at (23.0072, 10.7085, 1.6)) Radius=fillet_radius Setback=0mm)
  Copper_trace_2067.fillet(Vertices=Copper_trace_2067.vertex(at (25.9272, 9.0226, 1.6)) Radius=fillet_radius Setback=0mm)
  Copper_trace_2067.thicken(copper_thickness)
  Rectangle7 = rectangle(corner=(-(board_X/4)-(W_50/2), -board_Y/2, 0mm), z_size=board_Z+copper_thickness, x_size=W_50)
  Rectangle8 = rectangle(corner=(-(board_X/4)-(W_50/2), -board_Y/2, 0mm), z_size=board_Z+copper_thickness, x_size=W_50)
  Rectangle8.mirror(point=(0mm, 0mm, 0mm), normal=(0mm, 1mm, 0mm))
  Rectangle8.move(-(Resistor_CtoC/2)- (W_50/2)*sin(split_angle) -L_Split*cos(split_angle), 0mm, 0mm)
  Rectangle9 = rectangle(corner=(-(board_X/4)-(W_50/2), -board_Y/2, 0mm), z_size=board_Z+copper_thickness, x_size=W_50)
  Rectangle9.mirror(point=(0mm, 0mm, 0mm), normal=(0mm, 1mm, 0mm))
  Rectangle9.move(-(Resistor_CtoC/2)- (W_50/2)*sin(split_angle) -L_Split*cos(split_angle), 0mm, 0mm)
  Rectangle9.mirror(point=(-board_X/4, 5.8328535mm, 1.6mm), normal=(1mm, 0mm, 0mm))
  Rectangle10 = rectangle(corner=(-(board_X/4)-(W_50/2), -board_Y/2, 0mm), z_size=board_Z+copper_thickness, x_size=W_50)
  Rectangle10.mirror(point=(0mm, 0mm, 0mm), normal=(1mm, 0mm, 0mm))
  Rectangle11 = rectangle(corner=(-(board_X/4)-(W_50/2), -board_Y/2, 0mm), z_size=board_Z+copper_thickness, x_size=W_50)
  Rectangle11.mirror(point=(0mm, 0mm, 0mm), normal=(1mm, 0mm, 0mm))
  Rectangle11.mirror(point=(0mm, 0mm, 0mm), normal=(0mm, 1mm, 0mm))
  Rectangle11.move(-(Resistor_CtoC/2)- (W_50_2067/2)*sin(split_angle_2067) -L_split_2067*cos(split_angle_2067), 0mm, 0mm)
  Rectangle12 = rectangle(corner=(-(board_X/4)-(W_50/2), -board_Y/2, 0mm), z_size=board_Z+copper_thickness, x_size=W_50)
  Rectangle12.mirror(point=(0mm, 0mm, 0mm), normal=(1mm, 0mm, 0mm))
  Rectangle12.mirror(point=(0mm, 0mm, 0mm), normal=(0mm, 1mm, 0mm))
  Rectangle12.move(-(Resistor_CtoC/2)- (W_50_2067/2)*sin(split_angle_2067) -L_split_2067*cos(split_angle_2067), 0mm, 0mm)
  Rectangle12.mirror(point=(board_X/4, 7.0424311mm, 1.6mm), normal=(1mm, 0mm, 0mm))
boundaries and excitations:
  Ground: Perfect E Objects=Ground
  LumpRLC1: Lumped RLC Objects=Resistor_100ohms CurrentLine{(-17.675, 5.5828535, 1.6) -> (-17.325, 5.5828535, 1.6)} RLC_Type=Serial Resistance=100ohm
  Open1: Radiation Objects=RadiatingSurface
  LumpRLC2: Lumped RLC Objects=Resistor_100ohms_2067 CurrentLine{(17.325, 6.7924311, 1.6) -> (17.675, 6.7924311, 1.6)} RLC_Type=Serial Resistance=100ohm
  Port1: Terminal port=1 Faces=Copper_trace_2245.face(at (-17.5, -19, 1.6175)) TerminalResistance=50ohm
  Port2: Terminal port=2 Faces=Copper_trace_2245.face(at (-24.4672, 19, 1.6175)) TerminalResistance=50ohm
  Port3: Terminal port=3 Faces=Copper_trace_2245.face(at (-10.5328, 19, 1.6175)) TerminalResistance=50ohm
  Port4: Terminal port=4 Faces=Copper_trace_2067.face(at (17.5, -19, 1.6175)) TerminalResistance=50ohm
  Port5: Terminal port=5 Faces=Copper_trace_2067.face(at (10.5328, 19, 1.6175)) TerminalResistance=50ohm
  Port6: Terminal port=6 Faces=Copper_trace_2067.face(at (24.4672, 19, 1.6175)) TerminalResistance=50ohm
  1: Lumped Port Faces=Rectangle7.face LumpedPortType=Terminal Impedance=50ohm
  2: Lumped Port Faces=Rectangle8.face(at (-24.4672, 19, 0.8175)) LumpedPortType=Terminal Impedance=50ohm
  3: Lumped Port Faces=Rectangle9.face(at (-10.5328, 19, 0.8175)) LumpedPortType=Terminal Impedance=50ohm
  4: Lumped Port Faces=Rectangle10.face(at (17.5, -19, 0.8175)) LumpedPortType=Terminal Impedance=50ohm
  5: Lumped Port Faces=Rectangle11.face(at (10.5328, 19, 0.8175)) LumpedPortType=Terminal Impedance=50ohm
  6: Lumped Port Faces=Rectangle12.face(at (24.4672, 19, 0.8175)) LumpedPortType=Terminal Impedance=50ohm
  reference conductors: Ground
setups:
  both_frequencies: HfssDriven Frequency=5GHz MaxDeltaS=0.02 MaximumPasses=20 MinimumPasses=1 MinimumConvergedPasses=1 PercentRefinement=30 BasisOrder=1 PortAccuracy=2 DrivenSolverType="Direct Solver"
    sweep Sweep: 1GHz to 3.5GHz step 10MHz; Type=Interpolating InterpTolerance=0.5 InterpMaxSolns=250 PassivityErrorTolerance=0.0001
source amplitudes:
  1:1: 1V 0deg
  2:1, 3:1, 4:1, 5:1, 6:1: 0V 0deg
optimetrics:
  2067_arc: Parametric Sim._Setups=[both_frequencies]
    sweep quarterwave_2067: LIN 27.3mm 29.3mm 0.25mm
  2245_arc: Parametric Sim._Setups=[both_frequencies]
    sweep quarterwave_2245: LIN 25.4mm 27.4mm 0.25mm
  W_70p7_2067: Parametric Sim._Setups=[both_frequencies]
    sweep W_70p7_2067: LIN 1.3mm 1.6mm 0.05mm
  W_70p7_2245: Parametric Sim._Setups=[both_frequencies]
    sweep W_70p7: LIN 1.3mm 1.6mm 0.05mm
radiation setups:
  3D: Infinite Sphere Theta=0deg..180deg step 2deg Phi=-180deg..180deg step 2deg
  Elevation: Infinite Sphere Theta=-180deg..180deg step 1deg Phi=0deg..90deg step 90deg
  Azimuth: Infinite Sphere Theta=90deg..90deg step 0deg Phi=-180deg..180deg step 1deg
reports:
  Terminal S Parameter Plot1: dB(St(Port1,Port1)), dB(St(Port2,Port1)), dB(St(Port3,Port1)), dB(St(Port1,Port2)), dB(St(Port2,Port2)), dB(St(Port3,Port2)), dB(St(Port1,Port3)), dB(St(Port2,Port3)), dB(St(Port3,Port3)) vs Freq on both_frequencies : Sweep; markers MX1 at x=2.2447479e+09
  Terminal S Parameter Plot2: dB(St(Port4,Port4)), dB(St(Port5,Port4)), dB(St(Port6,Port4)), dB(St(Port4,Port5)), dB(St(Port5,Port5)), dB(St(Port6,Port5)), dB(St(Port4,Port6)), dB(St(Port5,Port6)), dB(St(Port6,Port6)) vs Freq on both_frequencies : Sweep [quarterwave_2067=27.3mm]; markers MX1 at x=2.0666488e+09
  Terminal S Parameter Plot3: dB(St(Port3,Port3)) vs Freq on both_frequencies : Sweep [quarterwave_2245=all]; markers MX1 at x=2.2447479e+09
  Terminal S Parameter Plot4: dB(St(Port4,Port4)) vs Freq on both_frequencies : Sweep [W_70p7_2067=all quarterwave_2067=28.3mm]; markers MX1 at x=2.0674895e+09

design Ideal_Wilkinson (Circuit)
options: SParamCircuitDef IntegrationMethod=FFT
components:
  A2 = TRLE_NX(F=2.245GHz)
  A3 = TRLE_NX(E=90deg Z=70.7 F=2.245GHz)
  R7 = RES_(R=100)
  A1 = TRLE_NX(E=90deg Z=70.7 F=2.245GHz)
  A4 = TRLE_NX(F=2.245GHz)
  A5 = TRLE_NX(F=2.245GHz)
  port Port1 rz=50ohm iz=0ohm EnableNoise=false noisetemp=16.85cel
  port Port2 rz=50ohm iz=0ohm EnableNoise=false noisetemp=16.85cel
  port Port3 rz=50ohm iz=0ohm EnableNoise=false noisetemp=16.85cel
nets:
  net_1: A3.0, A1.0, A2.1
  net_2: A4.0, A3.1, R7.1
  net_3: R7.0, A5.0, A1.1
  Port1: A2.0
  Port2: A4.1
  Port3: A5.1
setups:
  LinearFrequency: LinearFrequencyData(false, 0.1, false, "", false) SweepDefinition{Variable=Freq Data="LIN 1.8GHz 2.7GHz 0.01GHz"}
reports:
  S Parameter Plot1: dB(S(Port1,Port1)), dB(S(Port2,Port1)), dB(S(Port3,Port1)), dB(S(Port1,Port2)), dB(S(Port2,Port2)), dB(S(Port3,Port2)), dB(S(Port1,Port3)), dB(S(Port2,Port3)), dB(S(Port3,Port3)) vs Freq on LinearFrequency : LinearFrequency; markers MX1 at x=2.245e+09
